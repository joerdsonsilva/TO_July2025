* Equivalent circuit model for E:\touchstone_files\TL_Cap_diff_1.ckt
.SUBCKT TL_Cap_diff_1 po1 po2 po3 po4
Vsp1 po1 p1 0
Vsr1 p1 pr1 0
Rp1 pr1 0 50
Ru1 u1 0 50
Fr1 u1 0 Vsr1 -1
Fu1 u1 0 Vsp1 -1
Ry1 y1 0 1
Gy1 p1 0 y1 0 -0.02
Vsp2 po2 p2 0
Vsr2 p2 pr2 0
Rp2 pr2 0 50
Ru2 u2 0 50
Fr2 u2 0 Vsr2 -1
Fu2 u2 0 Vsp2 -1
Ry2 y2 0 1
Gy2 p2 0 y2 0 -0.02
Vsp3 po3 p3 0
Vsr3 p3 pr3 0
Rp3 pr3 0 50
Ru3 u3 0 50
Fr3 u3 0 Vsr3 -1
Fu3 u3 0 Vsp3 -1
Ry3 y3 0 1
Gy3 p3 0 y3 0 -0.02
Vsp4 po4 p4 0
Vsr4 p4 pr4 0
Rp4 pr4 0 50
Ru4 u4 0 50
Fr4 u4 0 Vsr4 -1
Fu4 u4 0 Vsp4 -1
Ry4 y4 0 1
Gy4 p4 0 y4 0 -0.02
Rx1 x1 0 1
Fxc1_2 x1 0 Vx2 3.34746116416968
Cx1 x1 xm1 1.37461890052371e-13
Vx1 xm1 0 0
Gx1_1 x1 0 u1 0 -0.169814680789666
Rx2 x2 0 1
Fxc2_1 x2 0 Vx1 -2.28338664943054
Cx2 x2 xm2 1.37461890052371e-13
Vx2 xm2 0 0
Gx2_1 x2 0 u1 0 0.387752574992432
Rx3 x3 0 1
Fxc3_4 x3 0 Vx4 2.68394883119189
Cx3 x3 xm3 8.2999706479009e-13
Vx3 xm3 0 0
Gx3_1 x3 0 u1 0 -0.549271942174717
Rx4 x4 0 1
Fxc4_3 x4 0 Vx3 -0.229020815688354
Cx4 x4 xm4 8.2999706479009e-13
Vx4 xm4 0 0
Gx4_1 x4 0 u1 0 0.12579470823158
Rx5 x5 0 1
Fxc5_6 x5 0 Vx6 1.13876839842099
Cx5 x5 xm5 2.63916190991037e-12
Vx5 xm5 0 0
Gx5_1 x5 0 u1 0 -0.511135201464266
Rx6 x6 0 1
Fxc6_5 x6 0 Vx5 -0.443122686303007
Cx6 x6 xm6 2.63916190991037e-12
Vx6 xm6 0 0
Gx6_1 x6 0 u1 0 0.226495603536874
Rx7 x7 0 1
Fxc7_8 x7 0 Vx8 0.30372502425736
Cx7 x7 xm7 1.05992093526139e-11
Vx7 xm7 0 0
Gx7_1 x7 0 u1 0 -0.703458242590963
Rx8 x8 0 1
Fxc8_7 x8 0 Vx7 -0.654967443892464
Cx8 x8 xm8 1.05992093526139e-11
Vx8 xm8 0 0
Gx8_1 x8 0 u1 0 0.460742247034888
Rx9 x9 0 1
Fxc9_10 x9 0 Vx10 58.9882736177284
Cx9 x9 xm9 3.49572616873061e-15
Vx9 xm9 0 0
Gx9_1 x9 0 u1 0 -0.00266803209861356
Rx10 x10 0 1
Fxc10_9 x10 0 Vx9 -103.38272010349
Cx10 x10 xm10 3.49572616873061e-15
Vx10 xm10 0 0
Gx10_1 x10 0 u1 0 0.275828415678093
Rx11 x11 0 1
Fxc11_12 x11 0 Vx12 12.4819367675163
Cx11 x11 xm11 6.52460300511876e-12
Vx11 xm11 0 0
Gx11_1 x11 0 u1 0 -0.0514690048474631
Rx12 x12 0 1
Fxc12_11 x12 0 Vx11 -0.226912557096762
Cx12 x12 xm12 6.52460300511876e-12
Vx12 xm12 0 0
Gx12_1 x12 0 u1 0 0.0116789635011635
Rx13 x13 0 1
Fxc13_14 x13 0 Vx14 46.0129362824563
Cx13 x13 xm13 1.11271124856823e-14
Vx13 xm13 0 0
Gx13_1 x13 0 u1 0 -1.84010680633707e-05
Rx14 x14 0 1
Fxc14_13 x14 0 Vx13 -56.7661685346225
Cx14 x14 xm14 1.11271124856823e-14
Vx14 xm14 0 0
Gx14_1 x14 0 u1 0 0.00104455813090236
Rx15 x15 0 1
Fxc15_16 x15 0 Vx16 46.996064436169
Cx15 x15 xm15 1.01238414175256e-14
Vx15 xm15 0 0
Gx15_1 x15 0 u1 0 -1.35481394284983e-05
Rx16 x16 0 1
Fxc16_15 x16 0 Vx15 -64.0921480131532
Cx16 x16 xm16 1.01238414175256e-14
Vx16 xm16 0 0
Gx16_1 x16 0 u1 0 0.00086832935755415
Rx17 x17 0 1
Fxc17_18 x17 0 Vx18 37.2451502099001
Cx17 x17 xm17 1.0980899452678e-14
Vx17 xm17 0 0
Gx17_1 x17 0 u1 0 -1.08608936358033e-05
Rx18 x18 0 1
Fxc18_17 x18 0 Vx17 -75.3554937886983
Cx18 x18 xm18 1.0980899452678e-14
Vx18 xm18 0 0
Gx18_1 x18 0 u1 0 0.000818428002912488
Rx19 x19 0 1
Fxc19_20 x19 0 Vx20 41.2271501775574
Cx19 x19 xm19 8.6531931888723e-15
Vx19 xm19 0 0
Gx19_1 x19 0 u1 0 -1.03816707677892e-05
Rx20 x20 0 1
Fxc20_19 x20 0 Vx19 -95.4300295675013
Cx20 x20 xm20 8.6531931888723e-15
Vx20 xm20 0 0
Gx20_1 x20 0 u1 0 0.000990723148330183
Rx21 x21 0 1
Fxc21_22 x21 0 Vx22 5.42268899110226
Cx21 x21 xm21 1.83704842905143e-12
Vx21 xm21 0 0
Gx21_1 x21 0 u1 0 -0.00161908320617674
Rx22 x22 0 1
Fxc22_21 x22 0 Vx21 -3.47893485684186
Cx22 x22 xm22 1.83704842905143e-12
Vx22 xm22 0 0
Gx22_1 x22 0 u1 0 0.00563268500209553
Rx23 x23 0 1
Fxc23_24 x23 0 Vx24 40.5598388793006
Cx23 x23 xm23 1.03097006532013e-14
Vx23 xm23 0 0
Gx23_1 x23 0 u1 0 -1.22723105639293e-05
Rx24 x24 0 1
Fxc24_23 x24 0 Vx23 -92.1813511107614
Cx24 x24 xm24 1.03097006532013e-14
Vx24 xm24 0 0
Gx24_1 x24 0 u1 0 0.00113127816903388
Rx25 x25 0 1
Fxc25_26 x25 0 Vx26 31.3112489728633
Cx25 x25 xm25 7.2343704950479e-15
Vx25 xm25 0 0
Gx25_1 x25 0 u1 0 -6.65273847528706e-06
Rx26 x26 0 1
Fxc26_25 x26 0 Vx25 -171.771937231968
Cx26 x26 xm26 7.2343704950479e-15
Vx26 xm26 0 0
Gx26_1 x26 0 u1 0 0.0011427537757977
Rx27 x27 0 1
Fxc27_28 x27 0 Vx28 33.5958559738244
Cx27 x27 xm27 9.20423935584287e-15
Vx27 xm27 0 0
Gx27_1 x27 0 u1 0 -4.51260354110523e-06
Rx28 x28 0 1
Fxc28_27 x28 0 Vx27 -133.07113763111
Cx28 x28 xm28 9.20423935584287e-15
Vx28 xm28 0 0
Gx28_1 x28 0 u1 0 0.000600497286893048
Rx29 x29 0 1
Fxc29_30 x29 0 Vx30 50.8674907575032
Cx29 x29 xm29 8.34940185748358e-15
Vx29 xm29 0 0
Gx29_1 x29 0 u1 0 -3.41700247328802e-06
Rx30 x30 0 1
Fxc30_29 x30 0 Vx29 -100.583819280073
Cx30 x30 xm30 8.34940185748358e-15
Vx30 xm30 0 0
Gx30_1 x30 0 u1 0 0.000343695159252765
Rx31 x31 0 1
Fxc31_32 x31 0 Vx32 1409.51265062753
Cx31 x31 xm31 5.89550865645947e-15
Vx31 xm31 0 0
Gx31_1 x31 0 u1 0 -1.65911601949033e-06
Rx32 x32 0 1
Fxc32_31 x32 0 Vx31 -8.55860895305141
Cx32 x32 xm32 5.89550865645947e-15
Vx32 xm32 0 0
Gx32_1 x32 0 u1 0 1.4199725218561e-05
Rx33 x33 0 1
Cx33 x33 0 2.14013258686195e-11
Gx33_1 x33 0 u1 0 -0.278730237431246
Rx34 x34 0 1
Fxc34_35 x34 0 Vx35 3.35047395091447
Cx34 x34 xm34 1.37461890052371e-13
Vx34 xm34 0 0
Gx34_2 x34 0 u2 0 -0.170137007544253
Rx35 x35 0 1
Fxc35_34 x35 0 Vx34 -2.28133340050773
Cx35 x35 xm35 1.37461890052371e-13
Vx35 xm35 0 0
Gx35_2 x35 0 u2 0 0.388139237973141
Rx36 x36 0 1
Fxc36_37 x36 0 Vx37 2.67142872188747
Cx36 x36 xm36 8.2999706479009e-13
Vx36 xm36 0 0
Gx36_2 x36 0 u2 0 -0.548733622197158
Rx37 x37 0 1
Fxc37_36 x37 0 Vx36 -0.230094161056663
Cx37 x37 xm37 8.2999706479009e-13
Vx37 xm37 0 0
Gx37_2 x37 0 u2 0 0.126260402443039
Rx38 x38 0 1
Fxc38_39 x38 0 Vx39 1.16388718123556
Cx38 x38 xm38 2.63916190991037e-12
Vx38 xm38 0 0
Gx38_2 x38 0 u2 0 -0.522821084082475
Rx39 x39 0 1
Fxc39_38 x39 0 Vx38 -0.433559300180274
Cx39 x39 xm39 2.63916190991037e-12
Vx39 xm39 0 0
Gx39_2 x39 0 u2 0 0.22667394333429
Rx40 x40 0 1
Fxc40_41 x40 0 Vx41 0.305548448968567
Cx40 x40 xm40 1.05992093526139e-11
Vx40 xm40 0 0
Gx40_2 x40 0 u2 0 -0.715007128253051
Rx41 x41 0 1
Fxc41_40 x41 0 Vx40 -0.651058787748858
Cx41 x41 xm41 1.05992093526139e-11
Vx41 xm41 0 0
Gx41_2 x41 0 u2 0 0.465511674152224
Rx42 x42 0 1
Fxc42_43 x42 0 Vx43 58.2747433778694
Cx42 x42 xm42 3.49572616873061e-15
Vx42 xm42 0 0
Gx42_2 x42 0 u2 0 -0.00263868832423259
Rx43 x43 0 1
Fxc43_42 x43 0 Vx42 -104.648563465414
Cx43 x43 xm43 3.49572616873061e-15
Vx43 xm43 0 0
Gx43_2 x43 0 u2 0 0.276134942563902
Rx44 x44 0 1
Fxc44_45 x44 0 Vx45 12.5848983840773
Cx44 x44 xm44 6.52460300511876e-12
Vx44 xm44 0 0
Gx44_2 x44 0 u2 0 -0.0519422136722063
Rx45 x45 0 1
Fxc45_44 x45 0 Vx44 -0.225056103195933
Cx45 x45 xm45 6.52460300511876e-12
Vx45 xm45 0 0
Gx45_2 x45 0 u2 0 0.0116899122004373
Rx46 x46 0 1
Fxc46_47 x46 0 Vx47 47.1605981250603
Cx46 x46 xm46 1.11271124856823e-14
Vx46 xm46 0 0
Gx46_2 x46 0 u2 0 -1.85491803861129e-05
Rx47 x47 0 1
Fxc47_46 x47 0 Vx46 -55.3847533667051
Cx47 x47 xm47 1.11271124856823e-14
Vx47 xm47 0 0
Gx47_2 x47 0 u2 0 0.00102734178083938
Rx48 x48 0 1
Fxc48_49 x48 0 Vx49 47.4297600471022
Cx48 x48 xm48 1.01238414175256e-14
Vx48 xm48 0 0
Gx48_2 x48 0 u2 0 -1.37621634281249e-05
Rx49 x49 0 1
Fxc49_48 x49 0 Vx48 -63.5060922696499
Cx49 x49 xm49 1.01238414175256e-14
Vx49 xm49 0 0
Gx49_2 x49 0 u2 0 0.000873981220496504
Rx50 x50 0 1
Fxc50_51 x50 0 Vx51 37.9047920048497
Cx50 x50 xm50 1.0980899452678e-14
Vx50 xm50 0 0
Gx50_2 x50 0 u2 0 -1.09684652060899e-05
Rx51 x51 0 1
Fxc51_50 x51 0 Vx50 -74.0441125476211
Cx51 x51 xm51 1.0980899452678e-14
Vx51 xm51 0 0
Gx51_2 x51 0 u2 0 0.00081215027219439
Rx52 x52 0 1
Fxc52_53 x52 0 Vx53 41.8961625162901
Cx52 x52 xm52 8.6531931888723e-15
Vx52 xm52 0 0
Gx52_2 x52 0 u2 0 -1.06047613288709e-05
Rx53 x53 0 1
Fxc53_52 x53 0 Vx52 -93.9061700197095
Cx53 x53 xm53 8.6531931888723e-15
Vx53 xm53 0 0
Gx53_2 x53 0 u2 0 0.00099585252036739
Rx54 x54 0 1
Fxc54_55 x54 0 Vx55 5.32255075714135
Cx54 x54 xm54 1.83704842905143e-12
Vx54 xm54 0 0
Gx54_2 x54 0 u2 0 -0.00161922734451216
Rx55 x55 0 1
Fxc55_54 x55 0 Vx54 -3.54438738299425
Cx55 x55 xm55 1.83704842905143e-12
Vx55 xm55 0 0
Gx55_2 x55 0 u2 0 0.00573916897008817
Rx56 x56 0 1
Fxc56_57 x56 0 Vx57 39.936054158139
Cx56 x56 xm56 1.03097006532013e-14
Vx56 xm56 0 0
Gx56_2 x56 0 u2 0 -1.20438028350021e-05
Rx57 x57 0 1
Fxc57_56 x57 0 Vx56 -93.6211858568592
Cx57 x57 xm57 1.03097006532013e-14
Vx57 xm57 0 0
Gx57_2 x57 0 u2 0 0.0011275551036391
Rx58 x58 0 1
Fxc58_59 x58 0 Vx59 31.7453585973098
Cx58 x58 xm58 7.2343704950479e-15
Vx58 xm58 0 0
Gx58_2 x58 0 u2 0 -6.76733243477251e-06
Rx59 x59 0 1
Fxc59_58 x59 0 Vx58 -169.423000113061
Cx59 x59 xm59 7.2343704950479e-15
Vx59 xm59 0 0
Gx59_2 x59 0 u2 0 0.00114654176386159
Rx60 x60 0 1
Fxc60_61 x60 0 Vx61 34.8822171565731
Cx60 x60 xm60 9.20423935584287e-15
Vx60 xm60 0 0
Gx60_2 x60 0 u2 0 -4.66221915030728e-06
Rx61 x61 0 1
Fxc61_60 x61 0 Vx60 -128.1638364345
Cx61 x61 xm61 9.20423935584287e-15
Vx61 xm61 0 0
Gx61_2 x61 0 u2 0 0.000597527892601774
Rx62 x62 0 1
Fxc62_63 x62 0 Vx63 51.0510755823798
Cx62 x62 xm62 8.34940185748358e-15
Vx62 xm62 0 0
Gx62_2 x62 0 u2 0 -3.40065284479652e-06
Rx63 x63 0 1
Fxc63_62 x63 0 Vx62 -100.222109705156
Cx63 x63 xm63 8.34940185748358e-15
Vx63 xm63 0 0
Gx63_2 x63 0 u2 0 0.000340820602480349
Rx64 x64 0 1
Fxc64_65 x64 0 Vx65 1643.9379369939
Cx64 x64 xm64 5.89550865645947e-15
Vx64 xm64 0 0
Gx64_2 x64 0 u2 0 -1.66066670387201e-06
Rx65 x65 0 1
Fxc65_64 x65 0 Vx64 -7.33815268790448
Cx65 x65 xm65 5.89550865645947e-15
Vx65 xm65 0 0
Gx65_2 x65 0 u2 0 1.21862258367319e-05
Rx66 x66 0 1
Cx66 x66 0 2.14013258686195e-11
Gx66_2 x66 0 u2 0 -0.281456612106033
Rx67 x67 0 1
Fxc67_68 x67 0 Vx68 3.31204036913932
Cx67 x67 xm67 1.37461890052371e-13
Vx67 xm67 0 0
Gx67_3 x67 0 u3 0 -0.169215833820629
Rx68 x68 0 1
Fxc68_67 x68 0 Vx67 -2.30780645156767
Cx68 x68 xm68 1.37461890052371e-13
Vx68 xm68 0 0
Gx68_3 x68 0 u3 0 0.39051739299865
Rx69 x69 0 1
Fxc69_70 x69 0 Vx70 2.44463240232931
Cx69 x69 xm69 8.2999706479009e-13
Vx69 xm69 0 0
Gx69_3 x69 0 u3 0 -0.560566065311972
Rx70 x70 0 1
Fxc70_69 x70 0 Vx69 -0.25144072785736
Cx70 x70 xm70 8.2999706479009e-13
Vx70 xm70 0 0
Gx70_3 x70 0 u3 0 0.140949139474179
Rx71 x71 0 1
Fxc71_72 x71 0 Vx72 1.38947264488549
Cx71 x71 xm71 2.63916190991037e-12
Vx71 xm71 0 0
Gx71_3 x71 0 u3 0 -0.540899084937641
Rx72 x72 0 1
Fxc72_71 x72 0 Vx71 -0.363169518768662
Cx72 x72 xm72 2.63916190991037e-12
Vx72 xm72 0 0
Gx72_3 x72 0 u3 0 0.196438060379213
Rx73 x73 0 1
Fxc73_74 x73 0 Vx74 0.297852769361229
Cx73 x73 xm73 1.05992093526139e-11
Vx73 xm73 0 0
Gx73_3 x73 0 u3 0 -0.703203193590699
Rx74 x74 0 1
Fxc74_73 x74 0 Vx73 -0.667880319564064
Cx74 x74 xm74 1.05992093526139e-11
Vx74 xm74 0 0
Gx74_3 x74 0 u3 0 0.469655573653827
Rx75 x75 0 1
Fxc75_76 x75 0 Vx76 59.4415893571329
Cx75 x75 xm75 3.49572616873061e-15
Vx75 xm75 0 0
Gx75_3 x75 0 u3 0 -0.00265411201304348
Rx76 x76 0 1
Fxc76_75 x76 0 Vx75 -102.594298819466
Cx76 x76 xm76 3.49572616873061e-15
Vx76 xm76 0 0
Gx76_3 x76 0 u3 0 0.272296760966518
Rx77 x77 0 1
Fxc77_78 x77 0 Vx78 14.1469839996649
Cx77 x77 xm77 6.52460300511876e-12
Vx77 xm77 0 0
Gx77_3 x77 0 u3 0 -0.0526846308798957
Rx78 x78 0 1
Fxc78_77 x78 0 Vx77 -0.200205795772746
Cx78 x78 xm78 6.52460300511876e-12
Vx78 xm78 0 0
Gx78_3 x78 0 u3 0 0.0105477684503029
Rx79 x79 0 1
Fxc79_80 x79 0 Vx80 45.1596333355682
Cx79 x79 xm79 1.11271124856823e-14
Vx79 xm79 0 0
Gx79_3 x79 0 u3 0 -1.80054213425212e-05
Rx80 x80 0 1
Fxc80_79 x80 0 Vx79 -57.8387799647066
Cx80 x80 xm80 1.11271124856823e-14
Vx80 xm80 0 0
Gx80_3 x80 0 u3 0 0.00104141160320192
Rx81 x81 0 1
Fxc81_82 x81 0 Vx82 45.4413638628343
Cx81 x81 xm81 1.01238414175256e-14
Vx81 xm81 0 0
Gx81_3 x81 0 u3 0 -1.30819760728799e-05
Rx82 x82 0 1
Fxc82_81 x82 0 Vx81 -66.2849540997636
Cx82 x82 xm82 1.01238414175256e-14
Vx82 xm82 0 0
Gx82_3 x82 0 u3 0 0.000867138183525049
Rx83 x83 0 1
Fxc83_84 x83 0 Vx84 37.5812044687628
Cx83 x83 xm83 1.0980899452678e-14
Vx83 xm83 0 0
Gx83_3 x83 0 u3 0 -1.07560021416134e-05
Rx84 x84 0 1
Fxc84_83 x84 0 Vx83 -74.68165869016
Cx84 x84 xm84 1.0980899452678e-14
Vx84 xm84 0 0
Gx84_3 x84 0 u3 0 0.0008032760808106
Rx85 x85 0 1
Fxc85_86 x85 0 Vx86 40.2679464864826
Cx85 x85 xm85 8.6531931888723e-15
Vx85 xm85 0 0
Gx85_3 x85 0 u3 0 -1.0076484135853e-05
Rx86 x86 0 1
Fxc86_85 x86 0 Vx85 -97.7032231268315
Cx86 x86 xm86 8.6531931888723e-15
Vx86 xm86 0 0
Gx86_3 x86 0 u3 0 0.000984504977859221
Rx87 x87 0 1
Fxc87_88 x87 0 Vx88 5.62587917736815
Cx87 x87 xm87 1.83704842905143e-12
Vx87 xm87 0 0
Gx87_3 x87 0 u3 0 -0.00169438994347279
Rx88 x88 0 1
Fxc88_87 x88 0 Vx87 -3.35328597614562
Cx88 x88 xm88 1.83704842905143e-12
Vx88 xm88 0 0
Gx88_3 x88 0 u3 0 0.00568177403556948
Rx89 x89 0 1
Fxc89_90 x89 0 Vx90 40.9091002320075
Cx89 x89 xm89 1.03097006532013e-14
Vx89 xm89 0 0
Gx89_3 x89 0 u3 0 -1.21842021791152e-05
Rx90 x90 0 1
Fxc90_89 x90 0 Vx89 -91.3943530296327
Cx90 x90 xm90 1.03097006532013e-14
Vx90 xm90 0 0
Gx90_3 x90 0 u3 0 0.00111356727534247
Rx91 x91 0 1
Fxc91_92 x91 0 Vx92 30.6369065152697
Cx91 x91 xm91 7.2343704950479e-15
Vx91 xm91 0 0
Gx91_3 x91 0 u3 0 -6.4604266314518e-06
Rx92 x92 0 1
Fxc92_91 x92 0 Vx91 -175.552772945289
Cx92 x92 xm92 7.2343704950479e-15
Vx92 xm92 0 0
Gx92_3 x92 0 u3 0 0.00113414580956096
Rx93 x93 0 1
Fxc93_94 x93 0 Vx94 34.3123394367374
Cx93 x93 xm93 9.20423935584287e-15
Vx93 xm93 0 0
Gx93_3 x93 0 u3 0 -4.54671410538703e-06
Rx94 x94 0 1
Fxc94_93 x94 0 Vx93 -130.292450107355
Cx94 x94 xm94 9.20423935584287e-15
Vx94 xm94 0 0
Gx94_3 x94 0 u3 0 0.000592402520728546
Rx95 x95 0 1
Fxc95_96 x95 0 Vx96 52.6923243546139
Cx95 x95 xm95 8.34940185748358e-15
Vx95 xm95 0 0
Gx95_3 x95 0 u3 0 -3.46699815217565e-06
Rx96 x96 0 1
Fxc96_95 x96 0 Vx95 -97.1004137746959
Cx96 x96 xm96 8.34940185748358e-15
Vx96 xm96 0 0
Gx96_3 x96 0 u3 0 0.000336646955132362
Rx97 x97 0 1
Fxc97_98 x97 0 Vx98 1266.2582037551
Cx97 x97 xm97 5.89550865645947e-15
Vx97 xm97 0 0
Gx97_3 x97 0 u3 0 -1.63773229951372e-06
Rx98 x98 0 1
Fxc98_97 x98 0 Vx97 -9.52686233765407
Cx98 x98 xm98 5.89550865645947e-15
Vx98 xm98 0 0
Gx98_3 x98 0 u3 0 1.56024501633968e-05
Rx99 x99 0 1
Cx99 x99 0 2.14013258686195e-11
Gx99_3 x99 0 u3 0 -0.284125541014638
Rx100 x100 0 1
Fxc100_101 x100 0 Vx101 3.31530991362762
Cx100 x100 xm100 1.37461890052371e-13
Vx100 xm100 0 0
Gx100_4 x100 0 u4 0 -0.169550576688142
Rx101 x101 0 1
Fxc101_100 x101 0 Vx100 -2.305530502694
Cx101 x101 xm101 1.37461890052371e-13
Vx101 xm101 0 0
Gx101_4 x101 0 u4 0 0.39090402630387
Rx102 x102 0 1
Fxc102_103 x102 0 Vx103 2.43420828006753
Cx102 x102 xm102 8.2999706479009e-13
Vx102 xm102 0 0
Gx102_4 x102 0 u4 0 -0.559948389481326
Rx103 x103 0 1
Fxc103_102 x103 0 Vx102 -0.252517484070146
Cx103 x103 xm103 8.2999706479009e-13
Vx103 xm103 0 0
Gx103_4 x103 0 u4 0 0.141396758520954
Rx104 x104 0 1
Fxc104_105 x104 0 Vx105 1.42236154940509
Cx104 x104 xm104 2.63916190991037e-12
Vx104 xm104 0 0
Gx104_4 x104 0 u4 0 -0.554414768262329
Rx105 x105 0 1
Fxc105_104 x105 0 Vx104 -0.354772042309736
Cx105 x105 xm105 2.63916190991037e-12
Vx105 xm105 0 0
Gx105_4 x105 0 u4 0 0.196690859623106
Rx106 x106 0 1
Fxc106_107 x106 0 Vx107 0.299494481085029
Cx106 x106 xm106 1.05992093526139e-11
Vx106 xm106 0 0
Gx106_4 x106 0 u4 0 -0.715894609439232
Rx107 x107 0 1
Fxc107_106 x107 0 Vx106 -0.664219260613157
Cx107 x107 xm107 1.05992093526139e-11
Vx107 xm107 0 0
Gx107_4 x107 0 u4 0 0.475510988158672
Rx108 x108 0 1
Fxc108_109 x108 0 Vx109 60.0607157848755
Cx108 x108 xm108 3.49572616873061e-15
Vx108 xm108 0 0
Gx108_4 x108 0 u4 0 -0.00268527928061486
Rx109 x109 0 1
Fxc109_108 x109 0 Vx108 -101.536721651016
Cx109 x109 xm109 3.49572616873061e-15
Vx109 xm109 0 0
Gx109_4 x109 0 u4 0 0.272654454871033
Rx110 x110 0 1
Fxc110_111 x110 0 Vx111 14.29342014231
Cx110 x110 xm110 6.52460300511876e-12
Vx110 xm110 0 0
Gx110_4 x110 0 u4 0 -0.0532909934720206
Rx111 x111 0 1
Fxc111_110 x111 0 Vx110 -0.198154686648669
Cx111 x111 xm111 6.52460300511876e-12
Vx111 xm111 0 0
Gx111_4 x111 0 u4 0 0.0105598601126445
Rx112 x112 0 1
Fxc112_113 x112 0 Vx113 46.4512267494473
Cx112 x112 xm112 1.11271124856823e-14
Vx112 xm112 0 0
Gx112_4 x112 0 u4 0 -1.81516208719886e-05
Rx113 x113 0 1
Fxc113_112 x113 0 Vx112 -56.2305514528491
Cx113 x113 xm113 1.11271124856823e-14
Vx113 xm113 0 0
Gx113_4 x113 0 u4 0 0.00102067565139496
Rx114 x114 0 1
Fxc114_115 x114 0 Vx115 46.20883178275
Cx114 x114 xm114 1.01238414175256e-14
Vx114 xm114 0 0
Gx114_4 x114 0 u4 0 -1.33910582646242e-05
Rx115 x115 0 1
Fxc115_114 x115 0 Vx114 -65.1840481932082
Cx115 x115 xm115 1.01238414175256e-14
Vx115 xm115 0 0
Gx115_4 x115 0 u4 0 0.000872883387279322
Rx116 x116 0 1
Fxc116_117 x116 0 Vx117 38.0295741223786
Cx116 x116 xm116 1.0980899452678e-14
Vx116 xm116 0 0
Gx116_4 x116 0 u4 0 -1.08635910164161e-05
Rx117 x117 0 1
Fxc117_116 x117 0 Vx116 -73.8011600200829
Cx117 x117 xm117 1.0980899452678e-14
Vx117 xm117 0 0
Gx117_4 x117 0 u4 0 0.000801745618995261
Rx118 x118 0 1
Fxc118_119 x118 0 Vx119 40.952418704371
Cx118 x118 xm118 8.6531931888723e-15
Vx118 xm118 0 0
Gx118_4 x118 0 u4 0 -1.03010727481222e-05
Rx119 x119 0 1
Fxc119_118 x119 0 Vx118 -96.0702269829106
Cx119 x119 xm119 8.6531931888723e-15
Vx119 xm119 0 0
Gx119_4 x119 0 u4 0 0.00098962639707957
Rx120 x120 0 1
Fxc120_121 x120 0 Vx121 5.52966400157748
Cx120 x120 xm120 1.83704842905143e-12
Vx120 xm120 0 0
Gx120_4 x120 0 u4 0 -0.00170023793577225
Rx121 x121 0 1
Fxc121_120 x121 0 Vx120 -3.41163255915305
Cx121 x121 xm121 1.83704842905143e-12
Vx121 xm121 0 0
Gx121_4 x121 0 u4 0 0.00580058709998776
Rx122 x122 0 1
Fxc122_123 x122 0 Vx123 41.3304940339632
Cx122 x122 xm122 1.03097006532013e-14
Vx122 xm122 0 0
Gx122_4 x122 0 u4 0 -1.22688110313027e-05
Rx123 x123 0 1
Fxc123_122 x123 0 Vx122 -90.4625225543232
Cx123 x123 xm123 1.03097006532013e-14
Vx123 xm123 0 0
Gx123_4 x123 0 u4 0 0.00110986759463395
Rx124 x124 0 1
Fxc124_125 x124 0 Vx125 30.8753304155776
Cx124 x124 xm124 7.2343704950479e-15
Vx124 xm124 0 0
Gx124_4 x124 0 u4 0 -6.53233502926001e-06
Rx125 x125 0 1
Fxc125_124 x125 0 Vx124 -174.197128284257
Cx125 x125 xm125 7.2343704950479e-15
Vx125 xm125 0 0
Gx125_4 x125 0 u4 0 0.00113791400308775
Rx126 x126 0 1
Fxc126_127 x126 0 Vx127 34.48253083022
Cx126 x126 xm126 9.20423935584287e-15
Vx126 xm126 0 0
Gx126_4 x126 0 u4 0 -4.59516994057696e-06
Rx127 x127 0 1
Fxc127_126 x127 0 Vx126 -129.649380903612
Cx127 x127 xm127 9.20423935584287e-15
Vx127 xm127 0 0
Gx127_4 x127 0 u4 0 0.000595760937942689
Rx128 x128 0 1
Fxc128_129 x128 0 Vx129 51.6070145836641
Cx128 x128 xm128 8.34940185748358e-15
Vx128 xm128 0 0
Gx128_4 x128 0 u4 0 -3.40333839185715e-06
Rx129 x129 0 1
Fxc129_128 x129 0 Vx128 -99.1424622962606
Cx129 x129 xm129 8.34940185748358e-15
Vx129 xm129 0 0
Gx129_4 x129 0 u4 0 0.000337415348196114
Rx130 x130 0 1
Fxc130_131 x130 0 Vx131 1280.30184703507
Cx130 x130 xm130 5.89550865645947e-15
Vx130 xm130 0 0
Gx130_4 x130 0 u4 0 -1.63929085497696e-06
Rx131 x131 0 1
Fxc131_130 x131 0 Vx130 -9.42236209299911
Cx131 x131 xm131 5.89550865645947e-15
Vx131 xm131 0 0
Gx131_4 x131 0 u4 0 1.5445992011335e-05
Rx132 x132 0 1
Cx132 x132 0 2.14013258686195e-11
Gx132_4 x132 0 u4 0 -0.28749738435172
Gyc1_1 y1 0 x1 0 -0.256406803126925
Gyc1_2 y1 0 x2 0 0.411833382962931
Gyc1_3 y1 0 x3 0 0.399479885379441
Gyc1_4 y1 0 x4 0 0.477435315641175
Gyc1_5 y1 0 x5 0 -1
Gyc1_6 y1 0 x6 0 0.412239915281083
Gyc1_7 y1 0 x7 0 -1
Gyc1_8 y1 0 x8 0 -1
Gyc1_9 y1 0 x9 0 -1
Gyc1_10 y1 0 x10 0 -0.405162156559839
Gyc1_11 y1 0 x11 0 1
Gyc1_12 y1 0 x12 0 0.200436122960966
Gyc1_13 y1 0 x13 0 0.408285222102774
Gyc1_14 y1 0 x14 0 -1
Gyc1_15 y1 0 x15 0 1
Gyc1_16 y1 0 x16 0 -0.640470023727877
Gyc1_17 y1 0 x17 0 -0.608963325629149
Gyc1_18 y1 0 x18 0 -1
Gyc1_19 y1 0 x19 0 1
Gyc1_20 y1 0 x20 0 -0.220689210030995
Gyc1_21 y1 0 x21 0 1
Gyc1_22 y1 0 x22 0 -1
Gyc1_23 y1 0 x23 0 -1
Gyc1_24 y1 0 x24 0 0.848355731148127
Gyc1_25 y1 0 x25 0 1
Gyc1_26 y1 0 x26 0 0.0104900157636602
Gyc1_27 y1 0 x27 0 -1
Gyc1_28 y1 0 x28 0 -1
Gyc1_29 y1 0 x29 0 -1
Gyc1_30 y1 0 x30 0 -1
Gyc1_31 y1 0 x31 0 0.457814849489083
Gyc1_32 y1 0 x32 0 1
Gyc1_33 y1 0 x33 0 -1
Gyc1_34 y1 0 x34 0 1
Gyc1_35 y1 0 x35 0 1
Gyc1_36 y1 0 x36 0 -1
Gyc1_37 y1 0 x37 0 -1
Gyc1_38 y1 0 x38 0 0.757125906389016
Gyc1_39 y1 0 x39 0 -1
Gyc1_40 y1 0 x40 0 0.563643163478484
Gyc1_41 y1 0 x41 0 0.402081561522681
Gyc1_42 y1 0 x42 0 0.640922207014066
Gyc1_43 y1 0 x43 0 1
Gyc1_44 y1 0 x44 0 -0.371920838388271
Gyc1_45 y1 0 x45 0 1
Gyc1_46 y1 0 x46 0 -1
Gyc1_47 y1 0 x47 0 -0.413840797564844
Gyc1_48 y1 0 x48 0 -0.961367614964717
Gyc1_49 y1 0 x49 0 -1
Gyc1_50 y1 0 x50 0 -1
Gyc1_51 y1 0 x51 0 0.218014492040749
Gyc1_52 y1 0 x52 0 -0.695736778118462
Gyc1_53 y1 0 x53 0 -1
Gyc1_54 y1 0 x54 0 -0.128917500146491
Gyc1_55 y1 0 x55 0 0.636082137566301
Gyc1_56 y1 0 x56 0 0.52451630608147
Gyc1_57 y1 0 x57 0 -1
Gyc1_58 y1 0 x58 0 -0.27010861677846
Gyc1_59 y1 0 x59 0 -1
Gyc1_60 y1 0 x60 0 0.30735842447298
Gyc1_61 y1 0 x61 0 0.423357934196973
Gyc1_62 y1 0 x62 0 -0.473670234612849
Gyc1_63 y1 0 x63 0 0.367913294709066
Gyc1_64 y1 0 x64 0 -1
Gyc1_65 y1 0 x65 0 -0.509551071613702
Gyc1_66 y1 0 x66 0 0.385661858896976
Gyc1_67 y1 0 x67 0 -0.302533532702232
Gyc1_68 y1 0 x68 0 0.339236952307971
Gyc1_69 y1 0 x69 0 0.303627422811742
Gyc1_70 y1 0 x70 0 -0.215121513929351
Gyc1_71 y1 0 x71 0 -0.0788529757375485
Gyc1_72 y1 0 x72 0 0.06610267461475
Gyc1_73 y1 0 x73 0 0.0495529368866177
Gyc1_74 y1 0 x74 0 0.0644771498645235
Gyc1_75 y1 0 x75 0 -0.594951177185512
Gyc1_76 y1 0 x76 0 -0.0648988189455786
Gyc1_77 y1 0 x77 0 -0.0679328746965881
Gyc1_78 y1 0 x78 0 -0.16354505019921
Gyc1_79 y1 0 x79 0 0.508152020166228
Gyc1_80 y1 0 x80 0 -0.635611721197926
Gyc1_81 y1 0 x81 0 0.848203263266153
Gyc1_82 y1 0 x82 0 -0.270803571896116
Gyc1_83 y1 0 x83 0 -0.200175617823534
Gyc1_84 y1 0 x84 0 -0.819536942270175
Gyc1_85 y1 0 x85 0 0.731671058883013
Gyc1_86 y1 0 x86 0 -0.0496710743058138
Gyc1_87 y1 0 x87 0 -0.0981197151606336
Gyc1_88 y1 0 x88 0 0.0284350746177385
Gyc1_89 y1 0 x89 0 -0.873175658426209
Gyc1_90 y1 0 x90 0 0.848330370186748
Gyc1_91 y1 0 x91 0 0.622431228936228
Gyc1_92 y1 0 x92 0 0.0576878450826448
Gyc1_93 y1 0 x93 0 -0.725511483461494
Gyc1_94 y1 0 x94 0 -0.894927847804863
Gyc1_95 y1 0 x95 0 -0.573174592505049
Gyc1_96 y1 0 x96 0 -0.896958273861404
Gyc1_97 y1 0 x97 0 0.565509678587011
Gyc1_98 y1 0 x98 0 -0.0474157987379538
Gyc1_99 y1 0 x99 0 0.0670906686669766
Gyc1_100 y1 0 x100 0 -0.0324075805364991
Gyc1_101 y1 0 x101 0 -0.166819216651636
Gyc1_102 y1 0 x102 0 -0.181130692590344
Gyc1_103 y1 0 x103 0 0.233318740144751
Gyc1_104 y1 0 x104 0 0.122793837886838
Gyc1_105 y1 0 x105 0 0.0514954290906115
Gyc1_106 y1 0 x106 0 0.0298343705606865
Gyc1_107 y1 0 x107 0 0.0400532277180816
Gyc1_108 y1 0 x108 0 0.0739148825696559
Gyc1_109 y1 0 x109 0 -0.0237710670104214
Gyc1_110 y1 0 x110 0 -0.0421702755194288
Gyc1_111 y1 0 x111 0 -0.0533284744868204
Gyc1_112 y1 0 x112 0 -0.467542076952995
Gyc1_113 y1 0 x113 0 0.771643812561888
Gyc1_114 y1 0 x114 0 -0.964556614560835
Gyc1_115 y1 0 x115 0 0.365262095551097
Gyc1_116 y1 0 x116 0 0.365559473190016
Gyc1_117 y1 0 x117 0 0.865806474588525
Gyc1_118 y1 0 x118 0 -0.853349412664906
Gyc1_119 y1 0 x119 0 -0.065924756214268
Gyc1_120 y1 0 x120 0 -0.0490912555232216
Gyc1_121 y1 0 x121 0 0.0379054794000616
Gyc1_122 y1 0 x122 0 0.926038166860002
Gyc1_123 y1 0 x123 0 -0.886811759642034
Gyc1_124 y1 0 x124 0 -0.671617351337799
Gyc1_125 y1 0 x125 0 -0.194964600034468
Gyc1_126 y1 0 x126 0 0.860890669203409
Gyc1_127 y1 0 x127 0 0.921232577758409
Gyc1_128 y1 0 x128 0 0.762912422971533
Gyc1_129 y1 0 x129 0 0.905522720406275
Gyc1_130 y1 0 x130 0 -0.559036248075496
Gyc1_131 y1 0 x131 0 -0.576437401544126
Gyc1_132 y1 0 x132 0 0.0390576954761441
Gyc2_1 y2 0 x1 0 1
Gyc2_2 y2 0 x2 0 1
Gyc2_3 y2 0 x3 0 -1
Gyc2_4 y2 0 x4 0 -1
Gyc2_5 y2 0 x5 0 0.775714449755512
Gyc2_6 y2 0 x6 0 -1
Gyc2_7 y2 0 x7 0 0.573329159182794
Gyc2_8 y2 0 x8 0 0.406853315169766
Gyc2_9 y2 0 x9 0 0.633481161472663
Gyc2_10 y2 0 x10 0 1
Gyc2_11 y2 0 x11 0 -0.375974948368308
Gyc2_12 y2 0 x12 0 1
Gyc2_13 y2 0 x13 0 -1
Gyc2_14 y2 0 x14 0 -0.404550965628429
Gyc2_15 y2 0 x15 0 -0.970926053319473
Gyc2_16 y2 0 x16 0 -1
Gyc2_17 y2 0 x17 0 -1
Gyc2_18 y2 0 x18 0 0.212874809824631
Gyc2_19 y2 0 x19 0 -0.709067505614531
Gyc2_20 y2 0 x20 0 -1
Gyc2_21 y2 0 x21 0 -0.129709088332688
Gyc2_22 y2 0 x22 0 0.648646419820863
Gyc2_23 y2 0 x23 0 0.502824544418873
Gyc2_24 y2 0 x24 0 -1
Gyc2_25 y2 0 x25 0 -0.27664892109055
Gyc2_26 y2 0 x26 0 -1
Gyc2_27 y2 0 x27 0 0.330762900535491
Gyc2_28 y2 0 x28 0 0.416246934690335
Gyc2_29 y2 0 x29 0 -0.462027954421983
Gyc2_30 y2 0 x30 0 0.358993732222034
Gyc2_31 y2 0 x31 0 -1
Gyc2_32 y2 0 x32 0 -0.381921810196177
Gyc2_33 y2 0 x33 0 0.39003778676147
Gyc2_34 y2 0 x34 0 -0.289199604155903
Gyc2_35 y2 0 x35 0 0.37940585697493
Gyc2_36 y2 0 x36 0 0.433537051732589
Gyc2_37 y2 0 x37 0 0.511655165183887
Gyc2_38 y2 0 x38 0 -1
Gyc2_39 y2 0 x39 0 0.446998202790701
Gyc2_40 y2 0 x40 0 -1
Gyc2_41 y2 0 x41 0 -1
Gyc2_42 y2 0 x42 0 -1
Gyc2_43 y2 0 x43 0 -0.431964027714637
Gyc2_44 y2 0 x44 0 1
Gyc2_45 y2 0 x45 0 0.163822710031053
Gyc2_46 y2 0 x46 0 0.42011443560105
Gyc2_47 y2 0 x47 0 -1
Gyc2_48 y2 0 x48 0 1
Gyc2_49 y2 0 x49 0 -0.612279557483057
Gyc2_50 y2 0 x50 0 -0.583602128533122
Gyc2_51 y2 0 x51 0 -1
Gyc2_52 y2 0 x52 0 1
Gyc2_53 y2 0 x53 0 -0.195690989607938
Gyc2_54 y2 0 x54 0 1
Gyc2_55 y2 0 x55 0 -1
Gyc2_56 y2 0 x56 0 -1
Gyc2_57 y2 0 x57 0 0.888634936710713
Gyc2_58 y2 0 x58 0 1
Gyc2_59 y2 0 x59 0 0.0401347707704007
Gyc2_60 y2 0 x60 0 -1
Gyc2_61 y2 0 x61 0 -1
Gyc2_62 y2 0 x62 0 -1
Gyc2_63 y2 0 x63 0 -1
Gyc2_64 y2 0 x64 0 0.489792207323921
Gyc2_65 y2 0 x65 0 1
Gyc2_66 y2 0 x66 0 -1
Gyc2_67 y2 0 x67 0 -0.0364144158466338
Gyc2_68 y2 0 x68 0 -0.167517707829781
Gyc2_69 y2 0 x69 0 -0.179777650633657
Gyc2_70 y2 0 x70 0 0.236253717846822
Gyc2_71 y2 0 x71 0 0.12602048802336
Gyc2_72 y2 0 x72 0 0.0530785557277906
Gyc2_73 y2 0 x73 0 0.0309024628664807
Gyc2_74 y2 0 x74 0 0.0413596932205677
Gyc2_75 y2 0 x75 0 0.0788605244400449
Gyc2_76 y2 0 x76 0 -0.0242500787752903
Gyc2_77 y2 0 x77 0 -0.0435218597182518
Gyc2_78 y2 0 x78 0 -0.0556626267803919
Gyc2_79 y2 0 x79 0 -0.457179707899409
Gyc2_80 y2 0 x80 0 0.756091718404728
Gyc2_81 y2 0 x81 0 -0.974766828124843
Gyc2_82 y2 0 x82 0 0.375397235139709
Gyc2_83 y2 0 x83 0 0.381582105942083
Gyc2_84 y2 0 x84 0 0.854574228078464
Gyc2_85 y2 0 x85 0 -0.866327082852649
Gyc2_86 y2 0 x86 0 -0.0589816788331595
Gyc2_87 y2 0 x87 0 -0.050569922975174
Gyc2_88 y2 0 x88 0 0.039117864740904
Gyc2_89 y2 0 x89 0 0.909250162875163
Gyc2_90 y2 0 x90 0 -0.883031341913619
Gyc2_91 y2 0 x91 0 -0.679551293137684
Gyc2_92 y2 0 x92 0 -0.190468636322002
Gyc2_93 y2 0 x93 0 0.883643954198867
Gyc2_94 y2 0 x94 0 0.913632315036469
Gyc2_95 y2 0 x95 0 0.758048813321831
Gyc2_96 y2 0 x96 0 0.893938603917503
Gyc2_97 y2 0 x97 0 -0.55454651177731
Gyc2_98 y2 0 x98 0 -0.492886064908405
Gyc2_99 y2 0 x99 0 0.0403557599789402
Gyc2_100 y2 0 x100 0 -0.301791417698656
Gyc2_101 y2 0 x101 0 0.346965243213446
Gyc2_102 y2 0 x102 0 0.311243236853857
Gyc2_103 y2 0 x103 0 -0.220950050084412
Gyc2_104 y2 0 x104 0 -0.0812633914340097
Gyc2_105 y2 0 x105 0 0.0654367023478827
Gyc2_106 y2 0 x106 0 0.0472725561736105
Gyc2_107 y2 0 x107 0 0.0619343163658643
Gyc2_108 y2 0 x108 0 -0.582140539818811
Gyc2_109 y2 0 x109 0 -0.068291647893065
Gyc2_110 y2 0 x110 0 -0.0653045419206565
Gyc2_111 y2 0 x111 0 -0.16065541835589
Gyc2_112 y2 0 x112 0 0.510070416537683
Gyc2_113 y2 0 x113 0 -0.673112755329248
Gyc2_114 y2 0 x114 0 0.851904789438239
Gyc2_115 y2 0 x115 0 -0.284481431246307
Gyc2_116 y2 0 x116 0 -0.219218017266259
Gyc2_117 y2 0 x117 0 -0.842580355346702
Gyc2_118 y2 0 x118 0 0.741338050917413
Gyc2_119 y2 0 x119 0 -0.0498968204341028
Gyc2_120 y2 0 x120 0 -0.0957615155148004
Gyc2_121 y2 0 x121 0 0.0266238810001895
Gyc2_122 y2 0 x122 0 -0.879730181323557
Gyc2_123 y2 0 x123 0 0.881953076747534
Gyc2_124 y2 0 x124 0 0.631578645941108
Gyc2_125 y2 0 x125 0 0.0639923460727702
Gyc2_126 y2 0 x126 0 -0.760571245460821
Gyc2_127 y2 0 x127 0 -0.910549978193511
Gyc2_128 y2 0 x128 0 -0.617759438729463
Gyc2_129 y2 0 x129 0 -0.914241964323893
Gyc2_130 y2 0 x130 0 0.580200938599204
Gyc2_131 y2 0 x131 0 -0.0809740647376821
Gyc2_132 y2 0 x132 0 0.0645950781427831
Gyc3_1 y3 0 x1 0 -0.303902367238894
Gyc3_2 y3 0 x2 0 0.344503702750615
Gyc3_3 y3 0 x3 0 0.309782164186774
Gyc3_4 y3 0 x4 0 -0.24225325212291
Gyc3_5 y3 0 x5 0 -0.0838017358388841
Gyc3_6 y3 0 x6 0 0.0570540251341534
Gyc3_7 y3 0 x7 0 0.048994128030667
Gyc3_8 y3 0 x8 0 0.0650498799899772
Gyc3_9 y3 0 x9 0 -0.605582188189187
Gyc3_10 y3 0 x10 0 -0.0705358483572038
Gyc3_11 y3 0 x11 0 -0.068828184561223
Gyc3_12 y3 0 x12 0 -0.14661288518609
Gyc3_13 y3 0 x13 0 0.496802501740436
Gyc3_14 y3 0 x14 0 -0.638608125941341
Gyc3_15 y3 0 x15 0 0.821856938941156
Gyc3_16 y3 0 x16 0 -0.276404060379941
Gyc3_17 y3 0 x17 0 -0.201959251071355
Gyc3_18 y3 0 x18 0 -0.807177586549949
Gyc3_19 y3 0 x19 0 0.715059015466175
Gyc3_20 y3 0 x20 0 -0.053854985631647
Gyc3_21 y3 0 x21 0 -0.101746203799696
Gyc3_22 y3 0 x22 0 0.0282471714199051
Gyc3_23 y3 0 x23 0 -0.864930162625892
Gyc3_24 y3 0 x24 0 0.835362994448013
Gyc3_25 y3 0 x25 0 0.615513965743753
Gyc3_26 y3 0 x26 0 0.0541079526462254
Gyc3_27 y3 0 x27 0 -0.733068993293934
Gyc3_28 y3 0 x28 0 -0.883512114772335
Gyc3_29 y3 0 x29 0 -0.584802650749667
Gyc3_30 y3 0 x30 0 -0.880226718273485
Gyc3_31 y3 0 x31 0 0.557830815314638
Gyc3_32 y3 0 x32 0 -0.0782400803467731
Gyc3_33 y3 0 x33 0 0.0676994635514175
Gyc3_34 y3 0 x34 0 -0.0340746408156792
Gyc3_35 y3 0 x35 0 -0.168743079414587
Gyc3_36 y3 0 x36 0 -0.185859790652273
Gyc3_37 y3 0 x37 0 0.263117028574001
Gyc3_38 y3 0 x38 0 0.129917259416458
Gyc3_39 y3 0 x39 0 0.0440815216287475
Gyc3_40 y3 0 x40 0 0.0295147764504517
Gyc3_41 y3 0 x41 0 0.0404693793226435
Gyc3_42 y3 0 x42 0 0.0776805550468042
Gyc3_43 y3 0 x43 0 -0.02696940649029
Gyc3_44 y3 0 x44 0 -0.0427914436674927
Gyc3_45 y3 0 x45 0 -0.0476778007380036
Gyc3_46 y3 0 x46 0 -0.449554482428027
Gyc3_47 y3 0 x47 0 0.767076485068771
Gyc3_48 y3 0 x48 0 -0.932196061854518
Gyc3_49 y3 0 x49 0 0.368625236601803
Gyc3_50 y3 0 x50 0 0.370859236821646
Gyc3_51 y3 0 x51 0 0.84976309299186
Gyc3_52 y3 0 x52 0 -0.825173555356477
Gyc3_53 y3 0 x53 0 -0.062797698595771
Gyc3_54 y3 0 x54 0 -0.0509961669675862
Gyc3_55 y3 0 x55 0 0.0379330267703156
Gyc3_56 y3 0 x56 0 0.928819761097811
Gyc3_57 y3 0 x57 0 -0.876971023411766
Gyc3_58 y3 0 x58 0 -0.644247233254764
Gyc3_59 y3 0 x59 0 -0.191950590817605
Gyc3_60 y3 0 x60 0 0.863095495904281
Gyc3_61 y3 0 x61 0 0.912084553932948
Gyc3_62 y3 0 x62 0 0.772739243654026
Gyc3_63 y3 0 x63 0 0.889073317672349
Gyc3_64 y3 0 x64 0 -0.551013235678281
Gyc3_65 y3 0 x65 0 -0.658904172190494
Gyc3_66 y3 0 x66 0 0.0394586709248124
Gyc3_67 y3 0 x67 0 -0.247749094451411
Gyc3_68 y3 0 x68 0 0.411853791973159
Gyc3_69 y3 0 x69 0 0.409933994640189
Gyc3_70 y3 0 x70 0 0.528965165839119
Gyc3_71 y3 0 x71 0 -1
Gyc3_72 y3 0 x72 0 0.323177205287735
Gyc3_73 y3 0 x73 0 -1
Gyc3_74 y3 0 x74 0 -1
Gyc3_75 y3 0 x75 0 -1
Gyc3_76 y3 0 x76 0 -0.408579792262772
Gyc3_77 y3 0 x77 0 1
Gyc3_78 y3 0 x78 0 0.33179397452601
Gyc3_79 y3 0 x79 0 0.385560801963163
Gyc3_80 y3 0 x80 0 -1
Gyc3_81 y3 0 x81 0 1
Gyc3_82 y3 0 x82 0 -0.653295766844594
Gyc3_83 y3 0 x83 0 -0.639605598029611
Gyc3_84 y3 0 x84 0 -1
Gyc3_85 y3 0 x85 0 1
Gyc3_86 y3 0 x86 0 -0.235225499716028
Gyc3_87 y3 0 x87 0 1
Gyc3_88 y3 0 x88 0 -1
Gyc3_89 y3 0 x89 0 -1
Gyc3_90 y3 0 x90 0 0.848952984756529
Gyc3_91 y3 0 x91 0 1
Gyc3_92 y3 0 x92 0 -0.005832735156105
Gyc3_93 y3 0 x93 0 -1
Gyc3_94 y3 0 x94 0 -1
Gyc3_95 y3 0 x95 0 -1
Gyc3_96 y3 0 x96 0 -1
Gyc3_97 y3 0 x97 0 0.447358031554089
Gyc3_98 y3 0 x98 0 1
Gyc3_99 y3 0 x99 0 -1
Gyc3_100 y3 0 x100 0 1
Gyc3_101 y3 0 x101 0 1
Gyc3_102 y3 0 x102 0 -1
Gyc3_103 y3 0 x103 0 -1
Gyc3_104 y3 0 x104 0 0.768609120826476
Gyc3_105 y3 0 x105 0 -1
Gyc3_106 y3 0 x106 0 0.561850022383988
Gyc3_107 y3 0 x107 0 0.411457249424102
Gyc3_108 y3 0 x108 0 0.62768111494658
Gyc3_109 y3 0 x109 0 1
Gyc3_110 y3 0 x110 0 -0.384434153952778
Gyc3_111 y3 0 x111 0 1
Gyc3_112 y3 0 x112 0 -1
Gyc3_113 y3 0 x113 0 -0.426726329155027
Gyc3_114 y3 0 x114 0 -0.958913876042347
Gyc3_115 y3 0 x115 0 -1
Gyc3_116 y3 0 x116 0 -1
Gyc3_117 y3 0 x117 0 0.201963859525228
Gyc3_118 y3 0 x118 0 -0.692122277183647
Gyc3_119 y3 0 x119 0 -1
Gyc3_120 y3 0 x120 0 -0.165925429487799
Gyc3_121 y3 0 x121 0 0.637619989703334
Gyc3_122 y3 0 x122 0 0.516018257209509
Gyc3_123 y3 0 x123 0 -1
Gyc3_124 y3 0 x124 0 -0.256349338660045
Gyc3_125 y3 0 x125 0 -1
Gyc3_126 y3 0 x126 0 0.304055644063404
Gyc3_127 y3 0 x127 0 0.412614703052281
Gyc3_128 y3 0 x128 0 -0.473056095792854
Gyc3_129 y3 0 x129 0 0.35301726673526
Gyc3_130 y3 0 x130 0 -1
Gyc3_131 y3 0 x131 0 -0.53959295780196
Gyc3_132 y3 0 x132 0 0.395338132172985
Gyc4_1 y4 0 x1 0 -0.0325107704050686
Gyc4_2 y4 0 x2 0 -0.168108759405981
Gyc4_3 y4 0 x3 0 -0.185320934918845
Gyc4_4 y4 0 x4 0 0.262928907910064
Gyc4_5 y4 0 x5 0 0.13321887722213
Gyc4_6 y4 0 x6 0 0.0444934685190489
Gyc4_7 y4 0 x7 0 0.0302542933133718
Gyc4_8 y4 0 x8 0 0.0411429073389392
Gyc4_9 y4 0 x9 0 0.0737434450362401
Gyc4_10 y4 0 x10 0 -0.0251704806304875
Gyc4_11 y4 0 x11 0 -0.0434495063029133
Gyc4_12 y4 0 x12 0 -0.0476448977083113
Gyc4_13 y4 0 x13 0 -0.454793489963103
Gyc4_14 y4 0 x14 0 0.749813517974623
Gyc4_15 y4 0 x15 0 -0.945004822135088
Gyc4_16 y4 0 x16 0 0.366531752668785
Gyc4_17 y4 0 x17 0 0.368102294060517
Gyc4_18 y4 0 x18 0 0.840839358753127
Gyc4_19 y4 0 x19 0 -0.83984851464641
Gyc4_20 y4 0 x20 0 -0.0650490068821107
Gyc4_21 y4 0 x21 0 -0.0512391060326916
Gyc4_22 y4 0 x22 0 0.0389676152610544
Gyc4_23 y4 0 x23 0 0.912652437195887
Gyc4_24 y4 0 x24 0 -0.867433305075674
Gyc4_25 y4 0 x25 0 -0.65171268077657
Gyc4_26 y4 0 x26 0 -0.192852170559581
Gyc4_27 y4 0 x27 0 0.880070996814169
Gyc4_28 y4 0 x28 0 0.905333743097513
Gyc4_29 y4 0 x29 0 0.760541994243806
Gyc4_30 y4 0 x30 0 0.880041995957242
Gyc4_31 y4 0 x31 0 -0.548567176521384
Gyc4_32 y4 0 x32 0 -0.592564091638184
Gyc4_33 y4 0 x33 0 0.0400901118971842
Gyc4_34 y4 0 x34 0 -0.303233694011533
Gyc4_35 y4 0 x35 0 0.352290316327297
Gyc4_36 y4 0 x36 0 0.317581300088407
Gyc4_37 y4 0 x37 0 -0.248663019782112
Gyc4_38 y4 0 x38 0 -0.0865404807223746
Gyc4_39 y4 0 x39 0 0.0565049811007551
Gyc4_40 y4 0 x40 0 0.0468089511637458
Gyc4_41 y4 0 x41 0 0.0626146698473517
Gyc4_42 y4 0 x42 0 -0.606211153102982
Gyc4_43 y4 0 x43 0 -0.0738285487678007
Gyc4_44 y4 0 x44 0 -0.0663373520258556
Gyc4_45 y4 0 x45 0 -0.144101537100165
Gyc4_46 y4 0 x46 0 0.498760092536107
Gyc4_47 y4 0 x47 0 -0.673722325452681
Gyc4_48 y4 0 x48 0 0.831721622267784
Gyc4_49 y4 0 x49 0 -0.290036440311075
Gyc4_50 y4 0 x50 0 -0.220751321113153
Gyc4_51 y4 0 x51 0 -0.834666186528524
Gyc4_52 y4 0 x52 0 0.724891713947787
Gyc4_53 y4 0 x53 0 -0.0540609305436323
Gyc4_54 y4 0 x54 0 -0.0997001410080257
Gyc4_55 y4 0 x55 0 0.0264590677091717
Gyc4_56 y4 0 x56 0 -0.894226312290497
Gyc4_57 y4 0 x57 0 0.86846991156752
Gyc4_58 y4 0 x58 0 0.620477278502373
Gyc4_59 y4 0 x59 0 0.0603459483249304
Gyc4_60 y4 0 x60 0 -0.751620996879363
Gyc4_61 y4 0 x61 0 -0.908562665719924
Gyc4_62 y4 0 x62 0 -0.621553807085904
Gyc4_63 y4 0 x63 0 -0.906852039176411
Gyc4_64 y4 0 x64 0 0.572362805805916
Gyc4_65 y4 0 x65 0 -0.133379098053525
Gyc4_66 y4 0 x66 0 0.0653074256146962
Gyc4_67 y4 0 x67 0 1
Gyc4_68 y4 0 x68 0 1
Gyc4_69 y4 0 x69 0 -1
Gyc4_70 y4 0 x70 0 -1
Gyc4_71 y4 0 x71 0 0.789085319979998
Gyc4_72 y4 0 x72 0 -1
Gyc4_73 y4 0 x73 0 0.572568520202101
Gyc4_74 y4 0 x74 0 0.417340692745975
Gyc4_75 y4 0 x75 0 0.634700241411671
Gyc4_76 y4 0 x76 0 1
Gyc4_77 y4 0 x77 0 -0.389650473923444
Gyc4_78 y4 0 x78 0 1
Gyc4_79 y4 0 x79 0 -1
Gyc4_80 y4 0 x80 0 -0.415612852251771
Gyc4_81 y4 0 x81 0 -0.975963625028599
Gyc4_82 y4 0 x82 0 -1
Gyc4_83 y4 0 x83 0 -1
Gyc4_84 y4 0 x84 0 0.198247704814771
Gyc4_85 y4 0 x85 0 -0.706045896102294
Gyc4_86 y4 0 x86 0 -1
Gyc4_87 y4 0 x87 0 -0.16744914860863
Gyc4_88 y4 0 x88 0 0.651646507090109
Gyc4_89 y4 0 x89 0 0.508043444628456
Gyc4_90 y4 0 x90 0 -1
Gyc4_91 y4 0 x91 0 -0.261260992100091
Gyc4_92 y4 0 x92 0 -1
Gyc4_93 y4 0 x93 0 0.320260748731558
Gyc4_94 y4 0 x94 0 0.410156982728729
Gyc4_95 y4 0 x95 0 -0.455152941540212
Gyc4_96 y4 0 x96 0 0.348139240142319
Gyc4_97 y4 0 x97 0 -1
Gyc4_98 y4 0 x98 0 -0.485712098887376
Gyc4_99 y4 0 x99 0 0.400771961326599
Gyc4_100 y4 0 x100 0 -0.281725330010335
Gyc4_101 y4 0 x101 0 0.371854711148849
Gyc4_102 y4 0 x102 0 0.44233264201877
Gyc4_103 y4 0 x103 0 0.567200472644043
Gyc4_104 y4 0 x104 0 -1
Gyc4_105 y4 0 x105 0 0.357581885758815
Gyc4_106 y4 0 x106 0 -1
Gyc4_107 y4 0 x107 0 -1
Gyc4_108 y4 0 x108 0 -1
Gyc4_109 y4 0 x109 0 -0.436354634843928
Gyc4_110 y4 0 x110 0 1
Gyc4_111 y4 0 x111 0 0.295067664900519
Gyc4_112 y4 0 x112 0 0.409438145333846
Gyc4_113 y4 0 x113 0 -1
Gyc4_114 y4 0 x114 0 1
Gyc4_115 y4 0 x115 0 -0.615510624901347
Gyc4_116 y4 0 x116 0 -0.599530434260504
Gyc4_117 y4 0 x117 0 -1
Gyc4_118 y4 0 x118 0 1
Gyc4_119 y4 0 x119 0 -0.20255595947265
Gyc4_120 y4 0 x120 0 1
Gyc4_121 y4 0 x121 0 -1
Gyc4_122 y4 0 x122 0 -1
Gyc4_123 y4 0 x123 0 0.883818400917496
Gyc4_124 y4 0 x124 0 1
Gyc4_125 y4 0 x125 0 0.0277742378016202
Gyc4_126 y4 0 x126 0 -1
Gyc4_127 y4 0 x127 0 -1
Gyc4_128 y4 0 x128 0 -1
Gyc4_129 y4 0 x129 0 -1
Gyc4_130 y4 0 x130 0 0.480560717024862
Gyc4_131 y4 0 x131 0 1
Gyc4_132 y4 0 x132 0 -1
.ENDS
