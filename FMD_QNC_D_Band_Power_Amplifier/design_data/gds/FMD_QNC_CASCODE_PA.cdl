* Extracted by KLayout with SG13G2 LVS runset on : 20/08/2025 18:50

.SUBCKT FMD_QNC_CASCODE_PA GND VCC VB1 VB4 VB6 VB2 VCC$1 VB5 VB3
Q$1 \$57 \$54 \$55 GND npn13G2 AE=0.063p PE=1.94u AB=63.456p PB=45.22u
+ AC=63.429884p PC=45.21u NE=10 m=10
Q$11 \$55 GND GND GND npn13G2 AE=0.063p PE=1.94u AB=63.456p PB=45.22u
+ AC=63.429884p PC=45.21u NE=10 m=10
Q$21 \$82 \$80 \$81 GND npn13G2 AE=0.063p PE=1.94u AB=63.456p PB=45.22u
+ AC=63.429884p PC=45.21u NE=10 m=10
Q$31 \$91 GND GND GND npn13G2 AE=0.063p PE=1.94u AB=25.605p PB=23.02u
+ AC=25.589984p PC=23.01u NE=4 m=4
Q$35 \$128 \$129 \$91 GND npn13G2 AE=0.063p PE=1.94u AB=63.456p PB=45.22u
+ AC=63.429884p PC=45.21u NE=10 m=10
Q$45 \$81 GND GND GND npn13G2 AE=0.063p PE=1.94u AB=50.839p PB=37.82u
+ AC=50.816584p PC=37.81u NE=8 m=8
R$53 \$17 \$18 rppd w=55u l=2u ps=0 b=0 m=1
R$54 \$26 \$27 rppd w=55u l=2u ps=0 b=0 m=1
R$55 \$169 \$167 rppd w=24u l=2.1u ps=0 b=0 m=1
R$56 VB1 GND rhigh w=8u l=3u ps=0 b=0 m=1
R$57 VB6 \$54 rhigh w=8u l=3u ps=0 b=0 m=1
R$58 VB4 \$80 rhigh w=8u l=3u ps=0 b=0 m=1
R$59 VB2 \$129 rhigh w=8u l=3u ps=0 b=0 m=1
R$60 GND VB5 rhigh w=8u l=3u ps=0 b=0 m=1
R$61 GND VB3 rhigh w=8u l=3u ps=0 b=0 m=1
C$62 VCC \$15 cap_cmim w=10u l=10u A=100p P=40u m=1
C$63 VCC \$16 cap_cmim w=10u l=10u A=100p P=40u m=1
C$64 VCC$1 \$189 cap_cmim w=10u l=10u A=100p P=40u m=1
R$65 GND GND ptap1 A=14.6016p P=74.88u
.ENDS FMD_QNC_CASCODE_PA
