* Equivalent circuit model for C:\Users\rupok\Documents\touchstone_files\passive.ckt
.SUBCKT passive po1 po2 po3
Vsp1 po1 p1 0
Vsr1 p1 pr1 0
Rp1 pr1 0 50
Ru1 u1 0 50
Fr1 u1 0 Vsr1 -1
Fu1 u1 0 Vsp1 -1
Ry1 y1 0 1
Gy1 p1 0 y1 0 -0.02
Vsp2 po2 p2 0
Vsr2 p2 pr2 0
Rp2 pr2 0 50
Ru2 u2 0 50
Fr2 u2 0 Vsr2 -1
Fu2 u2 0 Vsp2 -1
Ry2 y2 0 1
Gy2 p2 0 y2 0 -0.02
Vsp3 po3 p3 0
Vsr3 p3 pr3 0
Rp3 pr3 0 50
Ru3 u3 0 50
Fr3 u3 0 Vsr3 -1
Fu3 u3 0 Vsp3 -1
Ry3 y3 0 1
Gy3 p3 0 y3 0 -0.02
Rx1 x1 0 1
Fxc1_2 x1 0 Vx2 0.688512909673065
Cx1 x1 xm1 6.68451510666649e-13
Vx1 xm1 0 0
Gx1_1 x1 0 u1 0 -2.46686829349229
Rx2 x2 0 1
Fxc2_1 x2 0 Vx1 -0.52820040043402
Cx2 x2 xm2 6.68451510666649e-13
Vx2 xm2 0 0
Gx2_1 x2 0 u1 0 1.30300082044062
Rx3 x3 0 1
Fxc3_4 x3 0 Vx4 0.853545464300495
Cx3 x3 xm3 7.99780538538409e-14
Vx3 xm3 0 0
Gx3_1 x3 0 u1 0 -0.0811289260336919
Rx4 x4 0 1
Fxc4_3 x4 0 Vx3 -13.0514988273446
Cx4 x4 xm4 7.99780538538409e-14
Vx4 xm4 0 0
Gx4_1 x4 0 u1 0 1.05885408299246
Rx5 x5 0 1
Fxc5_6 x5 0 Vx6 1.5445327105808
Cx5 x5 xm5 1.72012473974169e-13
Vx5 xm5 0 0
Gx5_1 x5 0 u1 0 -0.1878094840998
Rx6 x6 0 1
Fxc6_5 x6 0 Vx5 -6.63707335424373
Cx6 x6 xm6 1.72012473974169e-13
Vx6 xm6 0 0
Gx6_1 x6 0 u1 0 1.24650532259304
Rx7 x7 0 1
Fxc7_8 x7 0 Vx8 14.9915496062085
Cx7 x7 xm7 1.01855344144997e-13
Vx7 xm7 0 0
Gx7_1 x7 0 u1 0 -0.338981114453347
Rx8 x8 0 1
Fxc8_7 x8 0 Vx7 -1.45560413262291
Cx8 x8 xm8 1.01855344144997e-13
Vx8 xm8 0 0
Gx8_1 x8 0 u1 0 0.49342231107941
Rx9 x9 0 1
Fxc9_10 x9 0 Vx10 0.401298455140929
Cx9 x9 xm9 1.01865246284245e-12
Vx9 xm9 0 0
Gx9_1 x9 0 u1 0 -0.838333913042956
Rx10 x10 0 1
Fxc10_9 x10 0 Vx9 -3.33675110334843
Cx10 x10 xm10 1.01865246284245e-12
Vx10 xm10 0 0
Gx10_1 x10 0 u1 0 2.79731160932049
Rx11 x11 0 1
Cx11 x11 0 2.99763443470512e-12
Gx11_1 x11 0 u1 0 -4.75385807852334
Rx12 x12 0 1
Fxc12_13 x12 0 Vx13 0.479126926079778
Cx12 x12 xm12 6.68451510666649e-13
Vx12 xm12 0 0
Gx12_2 x12 0 u2 0 -3.10149846344364
Rx13 x13 0 1
Fxc13_12 x13 0 Vx12 -0.759032262220953
Cx13 x13 xm13 6.68451510666649e-13
Vx13 xm13 0 0
Gx13_2 x13 0 u2 0 2.35413739498243
Rx14 x14 0 1
Fxc14_15 x14 0 Vx15 4.11234074566735
Cx14 x14 xm14 7.99780538538409e-14
Vx14 xm14 0 0
Gx14_2 x14 0 u2 0 -0.0802739321610053
Rx15 x15 0 1
Fxc15_14 x15 0 Vx14 -2.70893107244094
Cx15 x15 xm15 7.99780538538409e-14
Vx15 xm15 0 0
Gx15_2 x15 0 u2 0 0.217456549137963
Rx16 x16 0 1
Fxc16_17 x16 0 Vx17 2.82406828377615
Cx16 x16 xm16 1.72012473974169e-13
Vx16 xm16 0 0
Gx16_2 x16 0 u2 0 -0.230213106791053
Rx17 x17 0 1
Fxc17_16 x17 0 Vx16 -3.62993237700559
Cx17 x17 xm17 1.72012473974169e-13
Vx17 xm17 0 0
Gx17_2 x17 0 u2 0 0.835658009951888
Rx18 x18 0 1
Fxc18_19 x18 0 Vx19 4.33098022652911
Cx18 x18 xm18 1.01855344144997e-13
Vx18 xm18 0 0
Gx18_2 x18 0 u2 0 -0.0981218612079745
Rx19 x19 0 1
Fxc19_18 x19 0 Vx18 -5.03852717395263
Cx19 x19 xm19 1.01855344144997e-13
Vx19 xm19 0 0
Gx19_2 x19 0 u2 0 0.494389664055187
Rx20 x20 0 1
Fxc20_21 x20 0 Vx21 0.601630289796006
Cx20 x20 xm20 1.01865246284245e-12
Vx20 xm20 0 0
Gx20_2 x20 0 u2 0 -0.674002376218647
Rx21 x21 0 1
Fxc21_20 x21 0 Vx20 -2.22567428148862
Cx21 x21 xm21 1.01865246284245e-12
Vx21 xm21 0 0
Gx21_2 x21 0 u2 0 1.50010975441206
Rx22 x22 0 1
Cx22 x22 0 2.99763443470512e-12
Gx22_2 x22 0 u2 0 -0.59470905114284
Rx23 x23 0 1
Fxc23_24 x23 0 Vx24 0.478446696357828
Cx23 x23 xm23 6.68451510666649e-13
Vx23 xm23 0 0
Gx23_3 x23 0 u3 0 -3.08550583000042
Rx24 x24 0 1
Fxc24_23 x24 0 Vx23 -0.760111413375328
Cx24 x24 xm24 6.68451510666649e-13
Vx24 xm24 0 0
Gx24_3 x24 0 u3 0 2.34532819741944
Rx25 x25 0 1
Fxc25_26 x25 0 Vx26 9.05358213625998
Cx25 x25 xm25 7.99780538538409e-14
Vx25 xm25 0 0
Gx25_3 x25 0 u3 0 -0.15314805762787
Rx26 x26 0 1
Fxc26_25 x26 0 Vx25 -1.23045745415915
Cx26 x26 xm26 7.99780538538409e-14
Vx26 xm26 0 0
Gx26_3 x26 0 u3 0 0.188442169098208
Rx27 x27 0 1
Fxc27_28 x27 0 Vx28 2.34147613445527
Cx27 x27 xm27 1.72012473974169e-13
Vx27 xm27 0 0
Gx27_3 x27 0 u3 0 -0.231349868491394
Rx28 x28 0 1
Fxc28_27 x28 0 Vx27 -4.37808301665161
Cx28 x28 xm28 1.72012473974169e-13
Vx28 xm28 0 0
Gx28_3 x28 0 u3 0 1.01286893014675
Rx29 x29 0 1
Fxc29_30 x29 0 Vx30 9.07175732353465
Cx29 x29 xm29 1.01855344144997e-13
Vx29 xm29 0 0
Gx29_3 x29 0 u3 0 -0.0655139468248079
Rx30 x30 0 1
Fxc30_29 x30 0 Vx29 -2.40546134370314
Cx30 x30 xm30 1.01855344144997e-13
Vx30 xm30 0 0
Gx30_3 x30 0 u3 0 0.157591266560498
Rx31 x31 0 1
Fxc31_32 x31 0 Vx32 0.796670591266449
Cx31 x31 xm31 1.01865246284245e-12
Vx31 xm31 0 0
Gx31_3 x31 0 u3 0 -0.841485397363793
Rx32 x32 0 1
Fxc32_31 x32 0 Vx31 -1.68078635968586
Cx32 x32 xm32 1.01865246284245e-12
Vx32 xm32 0 0
Gx32_3 x32 0 u3 0 1.4143571777639
Rx33 x33 0 1
Cx33 x33 0 2.99763443470512e-12
Gx33_3 x33 0 u3 0 -0.784064914919339
Gyc1_1 y1 0 x1 0 1
Gyc1_2 y1 0 x2 0 0.828123514693055
Gyc1_3 y1 0 x3 0 -1
Gyc1_4 y1 0 x4 0 -1
Gyc1_5 y1 0 x5 0 1
Gyc1_6 y1 0 x6 0 1
Gyc1_7 y1 0 x7 0 -1
Gyc1_8 y1 0 x8 0 -0.209916551839572
Gyc1_9 y1 0 x9 0 -0.144135516325074
Gyc1_10 y1 0 x10 0 -1
Gyc1_11 y1 0 x11 0 -1
Gyc1_12 y1 0 x12 0 -0.238142792057858
Gyc1_13 y1 0 x13 0 -0.549727929155425
Gyc1_14 y1 0 x14 0 0.912896486317978
Gyc1_15 y1 0 x15 0 -0.937926410143131
Gyc1_16 y1 0 x16 0 -0.637601959166684
Gyc1_17 y1 0 x17 0 1
Gyc1_18 y1 0 x18 0 -0.121316254555405
Gyc1_19 y1 0 x19 0 -1
Gyc1_20 y1 0 x20 0 0.848444177791471
Gyc1_21 y1 0 x21 0 1
Gyc1_22 y1 0 x22 0 1
Gyc1_23 y1 0 x23 0 -0.0636528080110527
Gyc1_24 y1 0 x24 0 0.262911121528336
Gyc1_25 y1 0 x25 0 0.276076195173183
Gyc1_26 y1 0 x26 0 -0.413588903416471
Gyc1_27 y1 0 x27 0 -0.0592539855650125
Gyc1_28 y1 0 x28 0 -1
Gyc1_29 y1 0 x29 0 1
Gyc1_30 y1 0 x30 0 1
Gyc1_31 y1 0 x31 0 -1
Gyc1_32 y1 0 x32 0 -1
Gyc1_33 y1 0 x33 0 -1
Gyc2_1 y2 0 x1 0 -0.30297396056702
Gyc2_2 y2 0 x2 0 -1
Gyc2_3 y2 0 x3 0 0.896911878798952
Gyc2_4 y2 0 x4 0 -0.212641627852325
Gyc2_5 y2 0 x5 0 -0.765862344044843
Gyc2_6 y2 0 x6 0 0.680831326640658
Gyc2_7 y2 0 x7 0 -0.0465224673833724
Gyc2_8 y2 0 x8 0 -1
Gyc2_9 y2 0 x9 0 0.681244537573749
Gyc2_10 y2 0 x10 0 0.537083874331667
Gyc2_11 y2 0 x11 0 0.124432507405032
Gyc2_12 y2 0 x12 0 0.115242594258218
Gyc2_13 y2 0 x13 0 -0.0896298306877731
Gyc2_14 y2 0 x14 0 -1
Gyc2_15 y2 0 x15 0 -1
Gyc2_16 y2 0 x16 0 -0.529717250187058
Gyc2_17 y2 0 x17 0 0.287022017334626
Gyc2_18 y2 0 x18 0 1
Gyc2_19 y2 0 x19 0 0.0926733728627858
Gyc2_20 y2 0 x20 0 -0.852655643356749
Gyc2_21 y2 0 x21 0 -0.520755836421134
Gyc2_22 y2 0 x22 0 0.597396787893078
Gyc2_23 y2 0 x23 0 -1
Gyc2_24 y2 0 x24 0 -1
Gyc2_25 y2 0 x25 0 0.457013297597396
Gyc2_26 y2 0 x26 0 -1
Gyc2_27 y2 0 x27 0 1
Gyc2_28 y2 0 x28 0 -0.304033252901552
Gyc2_29 y2 0 x29 0 0.393616745593688
Gyc2_30 y2 0 x30 0 0.896034295547416
Gyc2_31 y2 0 x31 0 0.8017551358284
Gyc2_32 y2 0 x32 0 0.482041179487956
Gyc2_33 y2 0 x33 0 0.0798749866241676
Gyc3_1 y3 0 x1 0 -0.0715593122999273
Gyc3_2 y3 0 x2 0 0.49365846344586
Gyc3_3 y3 0 x3 0 0.510169583459979
Gyc3_4 y3 0 x4 0 -0.0658160616144963
Gyc3_5 y3 0 x5 0 -0.0874029601477802
Gyc3_6 y3 0 x6 0 -0.813025049648194
Gyc3_7 y3 0 x7 0 0.196810794424452
Gyc3_8 y3 0 x8 0 0.3157889036938
Gyc3_9 y3 0 x9 0 -1
Gyc3_10 y3 0 x10 0 -0.507486307586648
Gyc3_11 y3 0 x11 0 -0.163433296811472
Gyc3_12 y3 0 x12 0 -1
Gyc3_13 y3 0 x13 0 -1
Gyc3_14 y3 0 x14 0 0.888914655423242
Gyc3_15 y3 0 x15 0 -0.888354854151136
Gyc3_16 y3 0 x16 0 1
Gyc3_17 y3 0 x17 0 -0.37160809791819
Gyc3_18 y3 0 x18 0 0.265678887690453
Gyc3_19 y3 0 x19 0 0.27899020640511
Gyc3_20 y3 0 x20 0 1
Gyc3_21 y3 0 x21 0 0.455731057633086
Gyc3_22 y3 0 x22 0 0.102897761194174
Gyc3_23 y3 0 x23 0 0.4959101767569
Gyc3_24 y3 0 x24 0 -0.0474507038488541
Gyc3_25 y3 0 x25 0 -1
Gyc3_26 y3 0 x26 0 0.0616728092499171
Gyc3_27 y3 0 x27 0 -0.160097138572953
Gyc3_28 y3 0 x28 0 0.891883520192164
Gyc3_29 y3 0 x29 0 0.596011494087108
Gyc3_30 y3 0 x30 0 -0.497410411056852
Gyc3_31 y3 0 x31 0 -0.925506991440718
Gyc3_32 y3 0 x32 0 -0.482403064473822
Gyc3_33 y3 0 x33 0 0.509031619929904
.ENDS
