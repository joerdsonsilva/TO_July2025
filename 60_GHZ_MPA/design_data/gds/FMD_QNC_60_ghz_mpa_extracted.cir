* Extracted by KLayout with SG13G2 LVS runset on : 29/08/2025 08:49

.SUBCKT FMD_QNC_60_ghz_mpa GND VOUT VCC BIAS
Q$1 VCC \$40045 GND \$1 npn13G2 AE=0.063p PE=1.94u AB=63.456p PB=45.22u
+ AC=63.429884p PC=45.21u NE=10 m=10
R$11 \$40311 BIAS rppd w=2.5u l=22.86u ps=0 b=0 m=1
R$12 GND \$40311 rhigh w=5u l=18.12u ps=0 b=0 m=1
C$13 \$40311 GND cap_cmim w=18.19u l=18.2u A=331.058p P=72.78u m=1
C$14 VCC GND cap_cmim w=14.08u l=14.08u A=198.2464p P=56.32u m=2
C$15 VCC VOUT cap_cmim w=9.26u l=9.26u A=85.7476p P=37.04u m=1
C$17 VCC GND cap_cmim w=18.2u l=18.2u A=331.24p P=72.8u m=1
R$18 \$1 GND ptap1 A=6.084p P=31.2u
.ENDS FMD_QNC_60_ghz_mpa
