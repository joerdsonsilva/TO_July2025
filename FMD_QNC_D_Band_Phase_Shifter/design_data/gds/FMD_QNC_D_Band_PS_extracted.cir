* Extracted by KLayout with SG13G2 LVS runset on : 20/08/2025 09:04

.SUBCKT FMD_QNC_D_Band_PS GND VCC VBGAIN1 VBGAIN2 DSQ SQ VCQ VBBUF VCONGAIN1
+ VCONGAIN2 VCONGAIN3 VCONGAIN4 VBGAIN1$1 DSI SI VCI VBBUF$1
Q$1 \$139332 \$136664 GND GND npn13G2 AE=0.063p PE=1.94u AB=25.605p PB=23.02u
+ AC=25.589984p PC=23.01u NE=4 m=4
Q$5 \$138409 \$138409 GND GND npn13G2 AE=0.063p PE=1.94u AB=25.605p PB=23.02u
+ AC=25.589984p PC=23.01u NE=4 m=4
Q$9 \$138410 \$138410 GND GND npn13G2 AE=0.063p PE=1.94u AB=25.605p PB=23.02u
+ AC=25.589984p PC=23.01u NE=4 m=4
Q$13 \$140376 \$138195 \$139861 GND npn13G2 AE=0.063p PE=1.94u AB=25.605p
+ PB=23.02u AC=25.589984p PC=23.01u NE=4 m=4
Q$17 \$141437 \$141953 \$139861 GND npn13G2 AE=0.063p PE=1.94u AB=25.605p
+ PB=23.02u AC=25.589984p PC=23.01u NE=4 m=4
Q$21 \$140578 \$140376 \$139332 GND npn13G2 AE=0.063p PE=1.94u AB=25.605p
+ PB=23.02u AC=25.589984p PC=23.01u NE=4 m=4
Q$25 \$140376 \$141953 \$142941 GND npn13G2 AE=0.063p PE=1.94u AB=25.605p
+ PB=23.02u AC=25.589984p PC=23.01u NE=4 m=4
Q$29 \$142938 \$141437 \$139332 GND npn13G2 AE=0.063p PE=1.94u AB=25.605p
+ PB=23.02u AC=25.589984p PC=23.01u NE=4 m=4
Q$33 VCC \$143494 \$143493 GND npn13G2 AE=0.063p PE=1.94u AB=25.605p PB=23.02u
+ AC=25.589984p PC=23.01u NE=4 m=4
Q$37 VCC \$143497 \$143496 GND npn13G2 AE=0.063p PE=1.94u AB=25.605p PB=23.02u
+ AC=25.589984p PC=23.01u NE=4 m=4
Q$41 VCC \$143500 \$143499 GND npn13G2 AE=0.063p PE=1.94u AB=25.605p PB=23.02u
+ AC=25.589984p PC=23.01u NE=4 m=4
Q$45 VCC \$143503 \$143502 GND npn13G2 AE=0.063p PE=1.94u AB=25.605p PB=23.02u
+ AC=25.589984p PC=23.01u NE=4 m=4
Q$49 VCC \$140884 \$141955 GND npn13G2 AE=0.063p PE=1.94u AB=25.605p PB=23.02u
+ AC=25.589984p PC=23.01u NE=4 m=4
Q$53 \$143493 \$135337 \$144524 GND npn13G2 AE=0.063p PE=1.94u AB=25.605p
+ PB=23.02u AC=25.589984p PC=23.01u NE=4 m=4
Q$57 \$143496 \$135338 \$144525 GND npn13G2 AE=0.063p PE=1.94u AB=25.605p
+ PB=23.02u AC=25.589984p PC=23.01u NE=4 m=4
Q$61 \$143499 \$135339 \$144526 GND npn13G2 AE=0.063p PE=1.94u AB=25.605p
+ PB=23.02u AC=25.589984p PC=23.01u NE=4 m=4
Q$65 \$143502 \$135340 \$144527 GND npn13G2 AE=0.063p PE=1.94u AB=25.605p
+ PB=23.02u AC=25.589984p PC=23.01u NE=4 m=4
Q$69 VCC \$140885 \$141956 GND npn13G2 AE=0.063p PE=1.94u AB=25.605p PB=23.02u
+ AC=25.589984p PC=23.01u NE=4 m=4
Q$73 \$146553 \$145724 \$146058 GND npn13G2 AE=0.063p PE=1.94u AB=25.605p
+ PB=23.02u AC=25.589984p PC=23.01u NE=4 m=4
Q$77 \$141437 \$138195 \$142941 GND npn13G2 AE=0.063p PE=1.94u AB=25.605p
+ PB=23.02u AC=25.589984p PC=23.01u NE=4 m=4
Q$81 \$144524 \$144723 GND GND npn13G2 AE=0.063p PE=1.94u AB=25.605p PB=23.02u
+ AC=25.589984p PC=23.01u NE=4 m=4
Q$85 \$144525 \$144724 GND GND npn13G2 AE=0.063p PE=1.94u AB=25.605p PB=23.02u
+ AC=25.589984p PC=23.01u NE=4 m=4
Q$89 \$144526 \$144725 GND GND npn13G2 AE=0.063p PE=1.94u AB=25.605p PB=23.02u
+ AC=25.589984p PC=23.01u NE=4 m=4
Q$93 \$144527 \$144726 GND GND npn13G2 AE=0.063p PE=1.94u AB=25.605p PB=23.02u
+ AC=25.589984p PC=23.01u NE=4 m=4
Q$97 \$147063 \$146060 \$144524 GND npn13G2 AE=0.063p PE=1.94u AB=25.605p
+ PB=23.02u AC=25.589984p PC=23.01u NE=4 m=4
Q$101 \$147064 \$146061 \$144525 GND npn13G2 AE=0.063p PE=1.94u AB=25.605p
+ PB=23.02u AC=25.589984p PC=23.01u NE=4 m=4
Q$105 \$147065 \$146062 \$144526 GND npn13G2 AE=0.063p PE=1.94u AB=25.605p
+ PB=23.02u AC=25.589984p PC=23.01u NE=4 m=4
Q$109 \$147066 \$146063 \$144527 GND npn13G2 AE=0.063p PE=1.94u AB=25.605p
+ PB=23.02u AC=25.589984p PC=23.01u NE=4 m=4
Q$113 VCC \$146261 \$146757 GND npn13G2 AE=0.063p PE=1.94u AB=25.605p PB=23.02u
+ AC=25.589984p PC=23.01u NE=4 m=4
Q$117 VCC \$146266 \$146759 GND npn13G2 AE=0.063p PE=1.94u AB=25.605p PB=23.02u
+ AC=25.589984p PC=23.01u NE=4 m=4
Q$121 VCC \$143494 \$147063 GND npn13G2 AE=0.063p PE=1.94u AB=25.605p PB=23.02u
+ AC=25.589984p PC=23.01u NE=4 m=4
Q$125 VCC \$143497 \$147064 GND npn13G2 AE=0.063p PE=1.94u AB=25.605p PB=23.02u
+ AC=25.589984p PC=23.01u NE=4 m=4
Q$129 VCC \$143500 \$147065 GND npn13G2 AE=0.063p PE=1.94u AB=25.605p PB=23.02u
+ AC=25.589984p PC=23.01u NE=4 m=4
Q$133 VCC \$143503 \$147066 GND npn13G2 AE=0.063p PE=1.94u AB=25.605p PB=23.02u
+ AC=25.589984p PC=23.01u NE=4 m=4
Q$137 \$147575 \$147778 \$146058 GND npn13G2 AE=0.063p PE=1.94u AB=25.605p
+ PB=23.02u AC=25.589984p PC=23.01u NE=4 m=4
Q$141 \$146553 \$147778 \$148790 GND npn13G2 AE=0.063p PE=1.94u AB=25.605p
+ PB=23.02u AC=25.589984p PC=23.01u NE=4 m=4
Q$145 \$142938 \$147575 \$147624 GND npn13G2 AE=0.063p PE=1.94u AB=25.605p
+ PB=23.02u AC=25.589984p PC=23.01u NE=4 m=4
Q$149 \$140578 \$146553 \$147624 GND npn13G2 AE=0.063p PE=1.94u AB=25.605p
+ PB=23.02u AC=25.589984p PC=23.01u NE=4 m=4
Q$153 \$147575 \$145724 \$148790 GND npn13G2 AE=0.063p PE=1.94u AB=25.605p
+ PB=23.02u AC=25.589984p PC=23.01u NE=4 m=4
Q$157 \$150661 \$150661 GND GND npn13G2 AE=0.063p PE=1.94u AB=25.605p PB=23.02u
+ AC=25.589984p PC=23.01u NE=4 m=4
Q$161 \$150662 \$150662 GND GND npn13G2 AE=0.063p PE=1.94u AB=25.605p PB=23.02u
+ AC=25.589984p PC=23.01u NE=4 m=4
Q$165 \$147624 \$151736 GND GND npn13G2 AE=0.063p PE=1.94u AB=25.605p PB=23.02u
+ AC=25.589984p PC=23.01u NE=4 m=4
R$169 GND \$125611 rppd w=13u l=2u ps=0 b=0 m=1
R$170 \$133085 GND rppd w=13u l=2u ps=0 b=0 m=1
R$171 VBGAIN1 \$135337 rppd w=15u l=2u ps=0 b=0 m=1
R$172 VBGAIN1 \$135338 rppd w=15u l=2u ps=0 b=0 m=1
R$173 VBGAIN1 \$135339 rppd w=15u l=2u ps=0 b=0 m=1
R$174 VBGAIN1 \$135340 rppd w=15u l=2u ps=0 b=0 m=1
R$175 VCC \$140578 rppd w=12.5u l=6u ps=0 b=0 m=1
R$176 VBBUF \$140884 rppd w=15u l=2u ps=0 b=0 m=1
R$177 VBBUF \$140885 rppd w=15u l=2u ps=0 b=0 m=1
R$178 \$138409 \$141955 rppd w=8u l=6u ps=0 b=0 m=1
R$179 \$138410 \$141956 rppd w=8u l=6u ps=0 b=0 m=1
R$180 \$146757 \$150661 rppd w=8u l=6u ps=0 b=0 m=1
R$181 \$146759 \$150662 rppd w=8u l=6u ps=0 b=0 m=1
R$182 \$142938 VCC rppd w=12.5u l=6u ps=0 b=0 m=1
R$183 \$146261 VBBUF$1 rppd w=15u l=2u ps=0 b=0 m=1
R$184 \$146266 VBBUF$1 rppd w=15u l=2u ps=0 b=0 m=1
R$185 \$146060 VBGAIN1$1 rppd w=15u l=2u ps=0 b=0 m=1
R$186 \$146061 VBGAIN1$1 rppd w=15u l=2u ps=0 b=0 m=1
R$187 \$146062 VBGAIN1$1 rppd w=15u l=2u ps=0 b=0 m=1
R$188 \$146063 VBGAIN1$1 rppd w=15u l=2u ps=0 b=0 m=1
R$189 VCQ \$136664 rhigh w=4u l=2.1u ps=0 b=0 m=1
R$190 DSQ \$141953 rhigh w=4u l=2.1u ps=0 b=0 m=1
R$191 SQ \$138195 rhigh w=4u l=2.1u ps=0 b=0 m=1
R$192 \$135340 \$139501 rhigh w=4u l=5u ps=0 b=0 m=1
R$193 \$135337 \$139498 rhigh w=4u l=4u ps=0 b=0 m=1
R$194 \$135338 \$139499 rhigh w=4u l=4u ps=0 b=0 m=1
R$195 \$135339 \$139500 rhigh w=4u l=4u ps=0 b=0 m=1
R$196 GND \$139861 rhigh w=4u l=2.1u ps=0 b=0 m=1
R$197 VCC \$140376 rhigh w=4u l=2u ps=0 b=0 m=1
R$198 \$142941 GND rhigh w=4u l=2.1u ps=0 b=0 m=1
R$199 \$141437 VCC rhigh w=4u l=2u ps=0 b=0 m=1
R$200 \$144723 VCONGAIN1 rhigh w=4u l=2.1u ps=0 b=0 m=1
R$201 \$143494 VBGAIN2 rhigh w=4u l=2.1u ps=0 b=0 m=1
R$202 \$144724 VCONGAIN2 rhigh w=4u l=2.1u ps=0 b=0 m=1
R$203 \$143497 VBGAIN2 rhigh w=4u l=2.1u ps=0 b=0 m=1
R$204 \$144725 VCONGAIN3 rhigh w=4u l=2.1u ps=0 b=0 m=1
R$205 \$143500 VBGAIN2 rhigh w=4u l=2.1u ps=0 b=0 m=1
R$206 \$144726 VCONGAIN4 rhigh w=4u l=2.1u ps=0 b=0 m=1
R$207 \$143503 VBGAIN2 rhigh w=4u l=2.1u ps=0 b=0 m=1
R$208 \$148790 GND rhigh w=4u l=2.1u ps=0 b=0 m=1
R$209 GND \$146058 rhigh w=4u l=2.1u ps=0 b=0 m=1
R$210 VCC \$146553 rhigh w=4u l=2u ps=0 b=0 m=1
R$211 \$147575 VCC rhigh w=4u l=2u ps=0 b=0 m=1
R$212 \$149573 \$146060 rhigh w=4u l=4u ps=0 b=0 m=1
R$213 \$151685 \$146061 rhigh w=4u l=4u ps=0 b=0 m=1
R$214 \$151686 \$146062 rhigh w=4u l=4u ps=0 b=0 m=1
R$215 \$151687 \$146063 rhigh w=4u l=5u ps=0 b=0 m=1
R$216 \$147778 DSI rhigh w=4u l=2.1u ps=0 b=0 m=1
R$217 \$145724 SI rhigh w=4u l=2.1u ps=0 b=0 m=1
R$218 \$151736 VCI rhigh w=4u l=2.1u ps=0 b=0 m=1
C$219 VCC GND cap_cmim w=10u l=10u A=100p P=40u m=16
C$221 VBBUF GND cap_cmim w=20u l=20u A=400p P=80u m=2
C$223 DSQ GND cap_cmim w=20u l=20u A=400p P=80u m=1
C$224 SQ GND cap_cmim w=20u l=20u A=400p P=80u m=1
C$225 VCQ GND cap_cmim w=20u l=20u A=400p P=80u m=1
C$227 VBGAIN1 GND cap_cmim w=15u l=20u A=300p P=70u m=1
C$228 VCONGAIN1 GND cap_cmim w=15u l=20u A=300p P=70u m=2
C$229 VBGAIN2 GND cap_cmim w=15u l=20u A=300p P=70u m=8
C$230 VBGAIN1 GND cap_cmim w=20u l=20u A=400p P=80u m=3
C$231 VCONGAIN2 GND cap_cmim w=15u l=20u A=300p P=70u m=2
C$234 VCONGAIN3 GND cap_cmim w=15u l=20u A=300p P=70u m=2
C$237 VCONGAIN4 GND cap_cmim w=15u l=20u A=300p P=70u m=2
C$241 VBGAIN1$1 GND cap_cmim w=15u l=20u A=300p P=70u m=1
C$258 DSI GND cap_cmim w=20u l=20u A=400p P=80u m=1
C$259 SI GND cap_cmim w=20u l=20u A=400p P=80u m=1
C$261 VCI GND cap_cmim w=20u l=20u A=400p P=80u m=1
C$263 VBBUF$1 GND cap_cmim w=20u l=20u A=400p P=80u m=2
C$264 VBGAIN1$1 GND cap_cmim w=20u l=20u A=400p P=80u m=3
R$269 GND GND ptap1 A=36.504p P=187.2u
.ENDS FMD_QNC_D_Band_PS
