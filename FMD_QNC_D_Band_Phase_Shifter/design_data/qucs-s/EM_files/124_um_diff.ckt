* Equivalent circuit model for E:\touchstone_files\matlab\124_um_diff.ckt
.SUBCKT 124_um_diff po1 po2 po3 po4
Vsp1 po1 p1 0
Vsr1 p1 pr1 0
Rp1 pr1 0 50
Ru1 u1 0 50
Fr1 u1 0 Vsr1 -1
Fu1 u1 0 Vsp1 -1
Ry1 y1 0 1
Gy1 p1 0 y1 0 -0.02
Vsp2 po2 p2 0
Vsr2 p2 pr2 0
Rp2 pr2 0 50
Ru2 u2 0 50
Fr2 u2 0 Vsr2 -1
Fu2 u2 0 Vsp2 -1
Ry2 y2 0 1
Gy2 p2 0 y2 0 -0.02
Vsp3 po3 p3 0
Vsr3 p3 pr3 0
Rp3 pr3 0 50
Ru3 u3 0 50
Fr3 u3 0 Vsr3 -1
Fu3 u3 0 Vsp3 -1
Ry3 y3 0 1
Gy3 p3 0 y3 0 -0.02
Vsp4 po4 p4 0
Vsr4 p4 pr4 0
Rp4 pr4 0 50
Ru4 u4 0 50
Fr4 u4 0 Vsr4 -1
Fu4 u4 0 Vsp4 -1
Ry4 y4 0 1
Gy4 p4 0 y4 0 -0.02
Rx1 x1 0 1
Fxc1_2 x1 0 Vx2 0.700489293543076
Cx1 x1 xm1 3.14568053296022e-13
Vx1 xm1 0 0
Gx1_1 x1 0 u1 0 -1.19645694727238
Rx2 x2 0 1
Fxc2_1 x2 0 Vx1 -0.328857816256432
Cx2 x2 xm2 3.14568053296022e-13
Vx2 xm2 0 0
Gx2_1 x2 0 u1 0 0.393464218924832
Rx3 x3 0 1
Fxc3_4 x3 0 Vx4 4.50916792524342
Cx3 x3 xm3 1.39194087150078e-13
Vx3 xm3 0 0
Gx3_1 x3 0 u1 0 -0.385085289026766
Rx4 x4 0 1
Fxc4_3 x4 0 Vx3 -0.759694661242509
Cx4 x4 xm4 1.39194087150078e-13
Vx4 xm4 0 0
Gx4_1 x4 0 u1 0 0.292547238196663
Rx5 x5 0 1
Cx5 x5 0 9.1590180237952e-13
Gx5_1 x5 0 u1 0 -0.576211897084873
Rx6 x6 0 1
Cx6 x6 0 5.42750056078993e-12
Gx6_1 x6 0 u1 0 -0.0178579625951495
Rx7 x7 0 1
Fxc7_8 x7 0 Vx8 0.694796425492304
Cx7 x7 xm7 3.14568053296022e-13
Vx7 xm7 0 0
Gx7_2 x7 0 u2 0 -1.18211640542618
Rx8 x8 0 1
Fxc8_7 x8 0 Vx7 -0.331552338114523
Cx8 x8 xm8 3.14568053296022e-13
Vx8 xm8 0 0
Gx8_2 x8 0 u2 0 0.391933458142586
Rx9 x9 0 1
Fxc9_10 x9 0 Vx10 4.52664536028923
Cx9 x9 xm9 1.39194087150078e-13
Vx9 xm9 0 0
Gx9_2 x9 0 u2 0 -0.385522416285633
Rx10 x10 0 1
Fxc10_9 x10 0 Vx9 -0.756761470537316
Cx10 x10 xm10 1.39194087150078e-13
Vx10 xm10 0 0
Gx10_2 x10 0 u2 0 0.291748510673415
Rx11 x11 0 1
Cx11 x11 0 9.1590180237952e-13
Gx11_2 x11 0 u2 0 -0.575089274705883
Rx12 x12 0 1
Cx12 x12 0 5.42750056078993e-12
Gx12_2 x12 0 u2 0 -0.0177338967374458
Rx13 x13 0 1
Fxc13_14 x13 0 Vx14 0.700075167478264
Cx13 x13 xm13 3.14568053296022e-13
Vx13 xm13 0 0
Gx13_3 x13 0 u3 0 -1.19684468166744
Rx14 x14 0 1
Fxc14_13 x14 0 Vx13 -0.329052350500261
Cx14 x14 xm14 3.14568053296022e-13
Vx14 xm14 0 0
Gx14_3 x14 0 u3 0 0.393824555686408
Rx15 x15 0 1
Fxc15_16 x15 0 Vx16 4.51936057616951
Cx15 x15 xm15 1.39194087150078e-13
Vx15 xm15 0 0
Gx15_3 x15 0 u3 0 -0.386117491946811
Rx16 x16 0 1
Fxc16_15 x16 0 Vx15 -0.757981298840473
Cx16 x16 xm16 1.39194087150078e-13
Vx16 xm16 0 0
Gx16_3 x16 0 u3 0 0.292669838050869
Rx17 x17 0 1
Cx17 x17 0 9.1590180237952e-13
Gx17_3 x17 0 u3 0 -0.576818534650072
Rx18 x18 0 1
Cx18 x18 0 5.42750056078993e-12
Gx18_3 x18 0 u3 0 -0.0178901514681674
Rx19 x19 0 1
Fxc19_20 x19 0 Vx20 0.694454542544049
Cx19 x19 xm19 3.14568053296022e-13
Vx19 xm19 0 0
Gx19_4 x19 0 u4 0 -1.18200447728029
Rx20 x20 0 1
Fxc20_19 x20 0 Vx19 -0.331715562751862
Cx20 x20 xm20 3.14568053296022e-13
Vx20 xm20 0 0
Gx20_4 x20 0 u4 0 0.392089280356252
Rx21 x21 0 1
Fxc21_22 x21 0 Vx22 4.52179240341259
Cx21 x21 xm21 1.39194087150078e-13
Vx21 xm21 0 0
Gx21_4 x21 0 u4 0 -0.385059337352214
Rx22 x22 0 1
Fxc22_21 x22 0 Vx21 -0.757573655276191
Cx22 x22 xm22 1.39194087150078e-13
Vx22 xm22 0 0
Gx22_4 x22 0 u4 0 0.291710809696145
Rx23 x23 0 1
Cx23 x23 0 9.1590180237952e-13
Gx23_4 x23 0 u4 0 -0.574761799447074
Rx24 x24 0 1
Cx24 x24 0 5.42750056078993e-12
Gx24_4 x24 0 u4 0 -0.0177255840213725
Gyc1_1 y1 0 x1 0 -1
Gyc1_2 y1 0 x2 0 -1
Gyc1_3 y1 0 x3 0 0.40444855773619
Gyc1_4 y1 0 x4 0 -0.627227786339125
Gyc1_5 y1 0 x5 0 0.75721080513018
Gyc1_6 y1 0 x6 0 1
Gyc1_7 y1 0 x7 0 -0.333208694270408
Gyc1_8 y1 0 x8 0 0.979241046467161
Gyc1_9 y1 0 x9 0 1
Gyc1_10 y1 0 x10 0 0.0337196408042754
Gyc1_11 y1 0 x11 0 -1
Gyc1_12 y1 0 x12 0 -0.565964366561287
Gyc1_13 y1 0 x13 0 -0.410835188941554
Gyc1_14 y1 0 x14 0 -0.494156830233908
Gyc1_15 y1 0 x15 0 0.0169986432895776
Gyc1_16 y1 0 x16 0 0.472124950763922
Gyc1_17 y1 0 x17 0 0.725496673269373
Gyc1_18 y1 0 x18 0 0.282371235630137
Gyc1_19 y1 0 x19 0 0.414748889116236
Gyc1_20 y1 0 x20 0 -1
Gyc1_21 y1 0 x21 0 -0.296429090903751
Gyc1_22 y1 0 x22 0 1
Gyc1_23 y1 0 x23 0 -0.814137286309124
Gyc1_24 y1 0 x24 0 -0.129805114948242
Gyc2_1 y2 0 x1 0 -0.327618955396262
Gyc2_2 y2 0 x2 0 0.970048769213731
Gyc2_3 y2 0 x3 0 1
Gyc2_4 y2 0 x4 0 0.0418228437565883
Gyc2_5 y2 0 x5 0 -1
Gyc2_6 y2 0 x6 0 -0.566608905668801
Gyc2_7 y2 0 x7 0 -1
Gyc2_8 y2 0 x8 0 -0.991342756896074
Gyc2_9 y2 0 x9 0 0.398437489190099
Gyc2_10 y2 0 x10 0 -0.604839922255499
Gyc2_11 y2 0 x11 0 0.758420141782192
Gyc2_12 y2 0 x12 0 1
Gyc2_13 y2 0 x13 0 0.411241974990511
Gyc2_14 y2 0 x14 0 -0.991962723369458
Gyc2_15 y2 0 x15 0 -0.297320927886641
Gyc2_16 y2 0 x16 0 1
Gyc2_17 y2 0 x17 0 -0.809276854139389
Gyc2_18 y2 0 x18 0 -0.131344822625462
Gyc2_19 y2 0 x19 0 -0.415321879584053
Gyc2_20 y2 0 x20 0 -0.497808352813494
Gyc2_21 y2 0 x21 0 0.0153065984926223
Gyc2_22 y2 0 x22 0 0.471356388788595
Gyc2_23 y2 0 x23 0 0.725776052639692
Gyc2_24 y2 0 x24 0 0.281757992609938
Gyc3_1 y3 0 x1 0 -0.411310790605076
Gyc3_2 y3 0 x2 0 -0.494891092986025
Gyc3_3 y3 0 x3 0 0.0172479593759756
Gyc3_4 y3 0 x4 0 0.471611309129933
Gyc3_5 y3 0 x5 0 0.726281495644833
Gyc3_6 y3 0 x6 0 0.282690782405826
Gyc3_7 y3 0 x7 0 0.414886988553724
Gyc3_8 y3 0 x8 0 -1
Gyc3_9 y3 0 x9 0 -0.29623166349145
Gyc3_10 y3 0 x10 0 1
Gyc3_11 y3 0 x11 0 -0.813590291289962
Gyc3_12 y3 0 x12 0 -0.129936363639667
Gyc3_13 y3 0 x13 0 -1
Gyc3_14 y3 0 x14 0 -1
Gyc3_15 y3 0 x15 0 0.403677117391581
Gyc3_16 y3 0 x16 0 -0.627127308196206
Gyc3_17 y3 0 x17 0 0.756136638650501
Gyc3_18 y3 0 x18 0 1
Gyc3_19 y3 0 x19 0 -0.331861446278806
Gyc3_20 y3 0 x20 0 0.981767604875287
Gyc3_21 y3 0 x21 0 1
Gyc3_22 y3 0 x22 0 0.0348666656166046
Gyc3_23 y3 0 x23 0 -1
Gyc3_24 y3 0 x24 0 -0.567141593450704
Gyc4_1 y4 0 x1 0 0.410905343708724
Gyc4_2 y4 0 x2 0 -0.993855040126891
Gyc4_3 y4 0 x3 0 -0.297709159416642
Gyc4_4 y4 0 x4 0 1
Gyc4_5 y4 0 x5 0 -0.810323071137216
Gyc4_6 y4 0 x6 0 -0.131176243918092
Gyc4_7 y4 0 x7 0 -0.41501925478707
Gyc4_8 y4 0 x8 0 -0.4975844996458
Gyc4_9 y4 0 x9 0 0.0150886057260673
Gyc4_10 y4 0 x10 0 0.471642738717311
Gyc4_11 y4 0 x11 0 0.725422837974114
Gyc4_12 y4 0 x12 0 0.28155878813725
Gyc4_13 y4 0 x13 0 -0.330710995178217
Gyc4_14 y4 0 x14 0 0.963044287103454
Gyc4_15 y4 0 x15 0 1
Gyc4_16 y4 0 x16 0 0.0385098990300593
Gyc4_17 y4 0 x17 0 -1
Gyc4_18 y4 0 x18 0 -0.564684517822373
Gyc4_19 y4 0 x19 0 -1
Gyc4_20 y4 0 x20 0 -0.990692535639552
Gyc4_21 y4 0 x21 0 0.398828154728799
Gyc4_22 y4 0 x22 0 -0.604866091691994
Gyc4_23 y4 0 x23 0 0.758927426037493
Gyc4_24 y4 0 x24 0 1
.ENDS
