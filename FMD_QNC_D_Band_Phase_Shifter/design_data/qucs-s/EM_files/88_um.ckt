* Equivalent circuit model for E:\touchstone_files\88_um.ckt
.SUBCKT 88_um po1 po2 po3 po4
Vsp1 po1 p1 0
Vsr1 p1 pr1 0
Rp1 pr1 0 50
Ru1 u1 0 50
Fr1 u1 0 Vsr1 -1
Fu1 u1 0 Vsp1 -1
Ry1 y1 0 1
Gy1 p1 0 y1 0 -0.02
Vsp2 po2 p2 0
Vsr2 p2 pr2 0
Rp2 pr2 0 50
Ru2 u2 0 50
Fr2 u2 0 Vsr2 -1
Fu2 u2 0 Vsp2 -1
Ry2 y2 0 1
Gy2 p2 0 y2 0 -0.02
Vsp3 po3 p3 0
Vsr3 p3 pr3 0
Rp3 pr3 0 50
Ru3 u3 0 50
Fr3 u3 0 Vsr3 -1
Fu3 u3 0 Vsp3 -1
Ry3 y3 0 1
Gy3 p3 0 y3 0 -0.02
Vsp4 po4 p4 0
Vsr4 p4 pr4 0
Rp4 pr4 0 50
Ru4 u4 0 50
Fr4 u4 0 Vsr4 -1
Fu4 u4 0 Vsp4 -1
Ry4 y4 0 1
Gy4 p4 0 y4 0 -0.02
Rx1 x1 0 1
Fxc1_2 x1 0 Vx2 0.101793858327884
Cx1 x1 xm1 2.00856751783354e-13
Vx1 xm1 0 0
Gx1_1 x1 0 u1 0 -1.20866716170349
Rx2 x2 0 1
Fxc2_1 x2 0 Vx1 -0.514803886808286
Cx2 x2 xm2 2.00856751783354e-13
Vx2 xm2 0 0
Gx2_1 x2 0 u1 0 0.622226552702493
Rx3 x3 0 1
Fxc3_4 x3 0 Vx4 5.168519017421
Cx3 x3 xm3 1.24087018858907e-13
Vx3 xm3 0 0
Gx3_1 x3 0 u1 0 -0.315023038841733
Rx4 x4 0 1
Fxc4_3 x4 0 Vx3 -0.600655835307248
Cx4 x4 xm4 1.24087018858907e-13
Vx4 xm4 0 0
Gx4_1 x4 0 u1 0 0.189220426536509
Rx5 x5 0 1
Cx5 x5 0 6.89352095425544e-13
Gx5_1 x5 0 u1 0 -0.552542663381576
Rx6 x6 0 1
Fxc6_7 x6 0 Vx7 0.101696214824618
Cx6 x6 xm6 2.00856751783354e-13
Vx6 xm6 0 0
Gx6_2 x6 0 u2 0 -1.19062257830922
Rx7 x7 0 1
Fxc7_6 x7 0 Vx6 -0.51529817516592
Cx7 x7 xm7 2.00856751783354e-13
Vx7 xm7 0 0
Gx7_2 x7 0 u2 0 0.613525641914081
Rx8 x8 0 1
Fxc8_9 x8 0 Vx9 5.24883119267552
Cx8 x8 xm8 1.24087018858907e-13
Vx8 xm8 0 0
Gx8_2 x8 0 u2 0 -0.317364498910249
Rx9 x9 0 1
Fxc9_8 x9 0 Vx8 -0.591465222208439
Cx9 x9 xm9 1.24087018858907e-13
Vx9 xm9 0 0
Gx9_2 x9 0 u2 0 0.18771006386902
Rx10 x10 0 1
Cx10 x10 0 6.89352095425545e-13
Gx10_2 x10 0 u2 0 -0.55087322157033
Rx11 x11 0 1
Fxc11_12 x11 0 Vx12 0.101840484731519
Cx11 x11 xm11 2.00856751783354e-13
Vx11 xm11 0 0
Gx11_3 x11 0 u3 0 -1.20827214354911
Rx12 x12 0 1
Fxc12_11 x12 0 Vx11 -0.514568190229639
Cx12 x12 xm12 2.00856751783354e-13
Vx12 xm12 0 0
Gx12_3 x12 0 u3 0 0.621738410210951
Rx13 x13 0 1
Fxc13_14 x13 0 Vx14 5.16210953990291
Cx13 x13 xm13 1.24087018858907e-13
Vx13 xm13 0 0
Gx13_3 x13 0 u3 0 -0.316176431829316
Rx14 x14 0 1
Fxc14_13 x14 0 Vx13 -0.601401633133263
Cx14 x14 xm14 1.24087018858907e-13
Vx14 xm14 0 0
Gx14_3 x14 0 u3 0 0.190149022460399
Rx15 x15 0 1
Cx15 x15 0 6.89352095425544e-13
Gx15_3 x15 0 u3 0 -0.553119767105508
Rx16 x16 0 1
Fxc16_17 x16 0 Vx17 0.101696689905189
Cx16 x16 xm16 2.00856751783354e-13
Vx16 xm16 0 0
Gx16_4 x16 0 u4 0 -1.19061682254567
Rx17 x17 0 1
Fxc17_16 x17 0 Vx16 -0.515295767927773
Cx17 x17 xm17 2.00856751783354e-13
Vx17 xm17 0 0
Gx17_4 x17 0 u4 0 0.613519809881394
Rx18 x18 0 1
Fxc18_19 x18 0 Vx19 5.24880895539069
Cx18 x18 xm18 1.24087018858907e-13
Vx18 xm18 0 0
Gx18_4 x18 0 u4 0 -0.317363729985319
Rx19 x19 0 1
Fxc19_18 x19 0 Vx18 -0.591467728030374
Cx19 x19 xm19 1.24087018858907e-13
Vx19 xm19 0 0
Gx19_4 x19 0 u4 0 0.187710404333662
Rx20 x20 0 1
Cx20 x20 0 6.89352095425545e-13
Gx20_4 x20 0 u4 0 -0.55087356751995
Gyc1_1 y1 0 x1 0 -1
Gyc1_2 y1 0 x2 0 -1
Gyc1_3 y1 0 x3 0 0.585060507093654
Gyc1_4 y1 0 x4 0 0.56748250378326
Gyc1_5 y1 0 x5 0 0.898025633950995
Gyc1_6 y1 0 x6 0 0.0351179696157687
Gyc1_7 y1 0 x7 0 0.990739231290129
Gyc1_8 y1 0 x8 0 1
Gyc1_9 y1 0 x9 0 1
Gyc1_10 y1 0 x10 0 -1
Gyc1_11 y1 0 x11 0 -0.214184240962942
Gyc1_12 y1 0 x12 0 -0.0612457356797334
Gyc1_13 y1 0 x13 0 -0.253154477727469
Gyc1_14 y1 0 x14 0 0.811061575226566
Gyc1_15 y1 0 x15 0 0.814388808838404
Gyc1_16 y1 0 x16 0 0.396146544942875
Gyc1_17 y1 0 x17 0 -0.493015431107369
Gyc1_18 y1 0 x18 0 -0.61391597937196
Gyc1_19 y1 0 x19 0 0.653076974947431
Gyc1_20 y1 0 x20 0 -0.820770463850437
Gyc2_1 y2 0 x1 0 0.0391884772301467
Gyc2_2 y2 0 x2 0 0.976890075367056
Gyc2_3 y2 0 x3 0 1
Gyc2_4 y2 0 x4 0 1
Gyc2_5 y2 0 x5 0 -1
Gyc2_6 y2 0 x6 0 -1
Gyc2_7 y2 0 x7 0 -1
Gyc2_8 y2 0 x8 0 0.569074039945607
Gyc2_9 y2 0 x9 0 0.592472185323783
Gyc2_10 y2 0 x10 0 0.897503420388625
Gyc2_11 y2 0 x11 0 0.390437684518623
Gyc2_12 y2 0 x12 0 -0.486669951923663
Gyc2_13 y2 0 x13 0 -0.616938862736773
Gyc2_14 y2 0 x14 0 0.648957008466564
Gyc2_15 y2 0 x15 0 -0.815912348657353
Gyc2_16 y2 0 x16 0 -0.217585744968092
Gyc2_17 y2 0 x17 0 -0.0660276302660679
Gyc2_18 y2 0 x18 0 -0.253692287915698
Gyc2_19 y2 0 x19 0 0.818359559724888
Gyc2_20 y2 0 x20 0 0.813554453095655
Gyc3_1 y3 0 x1 0 -0.214929651464925
Gyc3_2 y3 0 x2 0 -0.0626867652290395
Gyc3_3 y3 0 x3 0 -0.253115690692327
Gyc3_4 y3 0 x4 0 0.815810576569192
Gyc3_5 y3 0 x5 0 0.815055298644504
Gyc3_6 y3 0 x6 0 0.39613931222387
Gyc3_7 y3 0 x7 0 -0.493021143135409
Gyc3_8 y3 0 x8 0 -0.613908178759802
Gyc3_9 y3 0 x9 0 0.653084929773745
Gyc3_10 y3 0 x10 0 -0.820772464414393
Gyc3_11 y3 0 x11 0 -1
Gyc3_12 y3 0 x12 0 -1
Gyc3_13 y3 0 x13 0 0.58252088588639
Gyc3_14 y3 0 x14 0 0.563990408963301
Gyc3_15 y3 0 x15 0 0.897244362004863
Gyc3_16 y3 0 x16 0 0.0351202136089518
Gyc3_17 y3 0 x17 0 0.990750368516771
Gyc3_18 y3 0 x18 0 1
Gyc3_19 y3 0 x19 0 1
Gyc3_20 y3 0 x20 0 -1
Gyc4_1 y4 0 x1 0 0.390102479738893
Gyc4_2 y4 0 x2 0 -0.486801609403112
Gyc4_3 y4 0 x3 0 -0.618933726376148
Gyc4_4 y4 0 x4 0 0.652652998600551
Gyc4_5 y4 0 x5 0 -0.816865660051955
Gyc4_6 y4 0 x6 0 -0.217586288818107
Gyc4_7 y4 0 x7 0 -0.0660309907657096
Gyc4_8 y4 0 x8 0 -0.253689486970929
Gyc4_9 y4 0 x9 0 0.818366158438986
Gyc4_10 y4 0 x10 0 0.813554506349633
Gyc4_11 y4 0 x11 0 0.036206538409884
Gyc4_12 y4 0 x12 0 0.97128745359634
Gyc4_13 y4 0 x13 0 1
Gyc4_14 y4 0 x14 0 1
Gyc4_15 y4 0 x15 0 -1
Gyc4_16 y4 0 x16 0 -1
Gyc4_17 y4 0 x17 0 -1
Gyc4_18 y4 0 x18 0 0.569069802798889
Gyc4_19 y4 0 x19 0 0.592465381546722
Gyc4_20 y4 0 x20 0 0.897504343038767
.ENDS
