* Equivalent circuit model for E:\touchstone_files\balun_coupler_together.ckt
.SUBCKT balun_coupler_together po1 po2 po3 po4 po5
Vsp1 po1 p1 0
Vsr1 p1 pr1 0
Rp1 pr1 0 50
Ru1 u1 0 50
Fr1 u1 0 Vsr1 -1
Fu1 u1 0 Vsp1 -1
Ry1 y1 0 1
Gy1 p1 0 y1 0 -0.02
Vsp2 po2 p2 0
Vsr2 p2 pr2 0
Rp2 pr2 0 50
Ru2 u2 0 50
Fr2 u2 0 Vsr2 -1
Fu2 u2 0 Vsp2 -1
Ry2 y2 0 1
Gy2 p2 0 y2 0 -0.02
Vsp3 po3 p3 0
Vsr3 p3 pr3 0
Rp3 pr3 0 50
Ru3 u3 0 50
Fr3 u3 0 Vsr3 -1
Fu3 u3 0 Vsp3 -1
Ry3 y3 0 1
Gy3 p3 0 y3 0 -0.02
Vsp4 po4 p4 0
Vsr4 p4 pr4 0
Rp4 pr4 0 50
Ru4 u4 0 50
Fr4 u4 0 Vsr4 -1
Fu4 u4 0 Vsp4 -1
Ry4 y4 0 1
Gy4 p4 0 y4 0 -0.02
Vsp5 po5 p5 0
Vsr5 p5 pr5 0
Rp5 pr5 0 50
Ru5 u5 0 50
Fr5 u5 0 Vsr5 -1
Fu5 u5 0 Vsp5 -1
Ry5 y5 0 1
Gy5 p5 0 y5 0 -0.02
Rx1 x1 0 1
Fxc1_2 x1 0 Vx2 0.063348856014664
Cx1 x1 xm1 4.04258367169137e-13
Vx1 xm1 0 0
Gx1_1 x1 0 u1 0 -0.581982711304118
Rx2 x2 0 1
Fxc2_1 x2 0 Vx1 -2.41270610681398
Cx2 x2 xm2 4.04258367169137e-13
Vx2 xm2 0 0
Gx2_1 x2 0 u1 0 1.4041532416236
Rx3 x3 0 1
Fxc3_4 x3 0 Vx4 2.68018839984296
Cx3 x3 xm3 2.48872873814249e-13
Vx3 xm3 0 0
Gx3_1 x3 0 u1 0 -0.287985270684047
Rx4 x4 0 1
Fxc4_3 x4 0 Vx3 -1.88693988927557
Cx4 x4 xm4 2.48872873814249e-13
Vx4 xm4 0 0
Gx4_1 x4 0 u1 0 0.54341089477755
Rx5 x5 0 1
Fxc5_6 x5 0 Vx6 2.27910632487494
Cx5 x5 xm5 5.73542300623674e-13
Vx5 xm5 0 0
Gx5_1 x5 0 u1 0 -1.11093713757122
Rx6 x6 0 1
Fxc6_5 x6 0 Vx5 -1.02257283048381
Cx6 x6 xm6 5.73542300623674e-13
Vx6 xm6 0 0
Gx6_1 x6 0 u1 0 1.13601413325579
Rx7 x7 0 1
Fxc7_8 x7 0 Vx8 6.48511995702183
Cx7 x7 xm7 1.54708334659554e-13
Vx7 xm7 0 0
Gx7_1 x7 0 u1 0 -0.0449350594931684
Rx8 x8 0 1
Fxc8_7 x8 0 Vx7 -2.34729413271935
Cx8 x8 xm8 1.54708334659554e-13
Vx8 xm8 0 0
Gx8_1 x8 0 u1 0 0.105475801501709
Rx9 x9 0 1
Fxc9_10 x9 0 Vx10 12.4517813110165
Cx9 x9 xm9 8.01223469558054e-14
Vx9 xm9 0 0
Gx9_1 x9 0 u1 0 -0.0178071143618361
Rx10 x10 0 1
Fxc10_9 x10 0 Vx9 -3.75682713878968
Cx10 x10 xm10 8.01223469558054e-14
Vx10 xm10 0 0
Gx10_1 x10 0 u1 0 0.0668982504980774
Rx11 x11 0 1
Fxc11_12 x11 0 Vx12 0.111064394929165
Cx11 x11 xm11 2.64430998425627e-12
Vx11 xm11 0 0
Gx11_1 x11 0 u1 0 -0.37648627154668
Rx12 x12 0 1
Fxc12_11 x12 0 Vx11 -5.09726670650219
Cx12 x12 xm12 2.64430998425627e-12
Vx12 xm12 0 0
Gx12_1 x12 0 u1 0 1.91905093741003
Rx13 x13 0 1
Fxc13_14 x13 0 Vx14 1.19366888948806
Cx13 x13 xm13 1.76980191855023e-12
Vx13 xm13 0 0
Gx13_1 x13 0 u1 0 -0.385634805521285
Rx14 x14 0 1
Fxc14_13 x14 0 Vx13 -1.28004068277316
Cx14 x14 xm14 1.76980191855023e-12
Vx14 xm14 0 0
Gx14_1 x14 0 u1 0 0.49362823976056
Rx15 x15 0 1
Fxc15_16 x15 0 Vx16 3.2038780116541
Cx15 x15 xm15 2.89949926104046e-14
Vx15 xm15 0 0
Gx15_1 x15 0 u1 0 -0.0015967248579055
Rx16 x16 0 1
Fxc16_15 x16 0 Vx15 -84.8254021297375
Cx16 x16 xm16 2.89949926104046e-14
Vx16 xm16 0 0
Gx16_1 x16 0 u1 0 0.135442828162382
Rx17 x17 0 1
Cx17 x17 0 1.21923886393338e-11
Gx17_1 x17 0 u1 0 -0.0507130732865053
Rx18 x18 0 1
Fxc18_19 x18 0 Vx19 0.224623512944836
Cx18 x18 xm18 4.04258367169137e-13
Vx18 xm18 0 0
Gx18_2 x18 0 u2 0 -1.02084467846607
Rx19 x19 0 1
Fxc19_18 x19 0 Vx18 -0.68043710011692
Cx19 x19 xm19 4.04258367169137e-13
Vx19 xm19 0 0
Gx19_2 x19 0 u2 0 0.694620592685244
Rx20 x20 0 1
Fxc20_21 x20 0 Vx21 2.88199850883464
Cx20 x20 xm20 2.48872873814249e-13
Vx20 xm20 0 0
Gx20_2 x20 0 u2 0 -0.727726106766316
Rx21 x21 0 1
Fxc21_20 x21 0 Vx20 -1.754808126005
Cx21 x21 xm21 2.48872873814249e-13
Vx21 xm21 0 0
Gx21_2 x21 0 u2 0 1.27701968565951
Rx22 x22 0 1
Fxc22_23 x22 0 Vx23 1.93128178028623
Cx22 x22 xm22 5.73542300623674e-13
Vx22 xm22 0 0
Gx22_2 x22 0 u2 0 -0.626507373546207
Rx23 x23 0 1
Fxc23_22 x23 0 Vx22 -1.20673856574959
Cx23 x23 xm23 5.73542300623673e-13
Vx23 xm23 0 0
Gx23_2 x23 0 u2 0 0.756030609384696
Rx24 x24 0 1
Fxc24_25 x24 0 Vx25 4.79972492328877
Cx24 x24 xm24 1.54708334659554e-13
Vx24 xm24 0 0
Gx24_2 x24 0 u2 0 -0.201501580224381
Rx25 x25 0 1
Fxc25_24 x25 0 Vx24 -3.17153259163612
Cx25 x25 xm25 1.54708334659554e-13
Vx25 xm25 0 0
Gx25_2 x25 0 u2 0 0.639068828947803
Rx26 x26 0 1
Fxc26_27 x26 0 Vx27 5.41298272354262
Cx26 x26 xm26 8.01223469558054e-14
Vx26 xm26 0 0
Gx26_2 x26 0 u2 0 -0.0239176049021667
Rx27 x27 0 1
Fxc27_26 x27 0 Vx26 -8.6420357028011
Cx27 x27 xm27 8.01223469558054e-14
Vx27 xm27 0 0
Gx27_2 x27 0 u2 0 0.206696795490015
Rx28 x28 0 1
Fxc28_29 x28 0 Vx29 0.446481068581246
Cx28 x28 xm28 2.64430998425627e-12
Vx28 xm28 0 0
Gx28_2 x28 0 u2 0 -0.858756155553247
Rx29 x29 0 1
Fxc29_28 x29 0 Vx28 -1.26797054206393
Cx29 x29 xm29 2.64430998425627e-12
Vx29 xm29 0 0
Gx29_2 x29 0 u2 0 1.08887750805759
Rx30 x30 0 1
Fxc30_31 x30 0 Vx31 1.6269036834542
Cx30 x30 xm30 1.76980191855023e-12
Vx30 xm30 0 0
Gx30_2 x30 0 u2 0 -0.845556332916304
Rx31 x31 0 1
Fxc31_30 x31 0 Vx30 -0.939173446986903
Cx31 x31 xm31 1.76980191855023e-12
Vx31 xm31 0 0
Gx31_2 x31 0 u2 0 0.79412405580661
Rx32 x32 0 1
Fxc32_33 x32 0 Vx33 46.3362306619747
Cx32 x32 xm32 2.89949926104046e-14
Vx32 xm32 0 0
Gx32_2 x32 0 u2 0 -0.00347376978552808
Rx33 x33 0 1
Fxc33_32 x33 0 Vx32 -5.86517800068292
Cx33 x33 xm33 2.89949926104046e-14
Vx33 xm33 0 0
Gx33_2 x33 0 u2 0 0.0203742781255163
Rx34 x34 0 1
Cx34 x34 0 1.21923886393338e-11
Gx34_2 x34 0 u2 0 -0.158357033149503
Rx35 x35 0 1
Fxc35_36 x35 0 Vx36 0.227368927100947
Cx35 x35 xm35 4.04258367169137e-13
Vx35 xm35 0 0
Gx35_3 x35 0 u3 0 -1.36879627354672
Rx36 x36 0 1
Fxc36_35 x36 0 Vx35 -0.672221018566889
Cx36 x36 xm36 4.04258367169137e-13
Vx36 xm36 0 0
Gx36_3 x36 0 u3 0 0.920133625214141
Rx37 x37 0 1
Fxc37_38 x37 0 Vx38 4.08865670340015
Cx37 x37 xm37 2.48872873814249e-13
Vx37 xm37 0 0
Gx37_3 x37 0 u3 0 -0.89103548805079
Rx38 x38 0 1
Fxc38_37 x38 0 Vx37 -1.2369232169166
Cx38 x38 xm38 2.48872873814249e-13
Vx38 xm38 0 0
Gx38_3 x38 0 u3 0 1.10214248226663
Rx39 x39 0 1
Fxc39_40 x39 0 Vx40 3.9159191395881
Cx39 x39 xm39 5.73542300623674e-13
Vx39 xm39 0 0
Gx39_3 x39 0 u3 0 -0.741829132547573
Rx40 x40 0 1
Fxc40_39 x40 0 Vx39 -0.595148194466056
Cx40 x40 xm40 5.73542300623674e-13
Vx40 xm40 0 0
Gx40_3 x40 0 u3 0 0.441498268838009
Rx41 x41 0 1
Fxc41_42 x41 0 Vx42 4.75017242574748
Cx41 x41 xm41 1.54708334659554e-13
Vx41 xm41 0 0
Gx41_3 x41 0 u3 0 -0.21208282077347
Rx42 x42 0 1
Fxc42_41 x42 0 Vx41 -3.20461715086123
Cx42 x42 xm42 1.54708334659554e-13
Vx42 xm42 0 0
Gx42_3 x42 0 u3 0 0.67964424485369
Rx43 x43 0 1
Fxc43_44 x43 0 Vx44 8.40149414921507
Cx43 x43 xm43 8.01223469558054e-14
Vx43 xm43 0 0
Gx43_3 x43 0 u3 0 -0.0250048974824471
Rx44 x44 0 1
Fxc44_43 x44 0 Vx43 -5.5679607846744
Cx44 x44 xm44 8.01223469558054e-14
Vx44 xm44 0 0
Gx44_3 x44 0 u3 0 0.139226288607069
Rx45 x45 0 1
Fxc45_46 x45 0 Vx46 0.765487907459196
Cx45 x45 xm45 2.64430998425627e-12
Vx45 xm45 0 0
Gx45_3 x45 0 u3 0 -0.863197314788232
Rx46 x46 0 1
Fxc46_45 x46 0 Vx45 -0.739560791272749
Cx46 x46 xm46 2.64430998425627e-12
Vx46 xm46 0 0
Gx46_3 x46 0 u3 0 0.638386889149297
Rx47 x47 0 1
Fxc47_48 x47 0 Vx48 1.59699946288684
Cx47 x47 xm47 1.76980191855023e-12
Vx47 xm47 0 0
Gx47_3 x47 0 u3 0 -1.270971451943
Rx48 x48 0 1
Fxc48_47 x48 0 Vx47 -0.956759708324108
Cx48 x48 xm48 1.76980191855023e-12
Vx48 xm48 0 0
Gx48_3 x48 0 u3 0 1.21601427564926
Rx49 x49 0 1
Fxc49_50 x49 0 Vx50 25.705570126276
Cx49 x49 xm49 2.89949926104046e-14
Vx49 xm49 0 0
Gx49_3 x49 0 u3 0 -0.00327355669243157
Rx50 x50 0 1
Fxc50_49 x50 0 Vx49 -10.5724261075767
Cx50 x50 xm50 2.89949926104046e-14
Vx50 xm50 0 0
Gx50_3 x50 0 u3 0 0.0346094362396959
Rx51 x51 0 1
Cx51 x51 0 1.21923886393338e-11
Gx51_3 x51 0 u3 0 -0.180879677934036
Rx52 x52 0 1
Fxc52_53 x52 0 Vx53 0.0534390119017333
Cx52 x52 xm52 4.04258367169137e-13
Vx52 xm52 0 0
Gx52_4 x52 0 u4 0 -1.34295514103734
Rx53 x53 0 1
Fxc53_52 x53 0 Vx52 -2.86012346274879
Cx53 x53 xm53 4.04258367169137e-13
Vx53 xm53 0 0
Gx53_4 x53 0 u4 0 3.84101750830001
Rx54 x54 0 1
Fxc54_55 x54 0 Vx55 1.53594317049561
Cx54 x54 xm54 2.48872873814249e-13
Vx54 xm54 0 0
Gx54_4 x54 0 u4 0 -0.921478980395721
Rx55 x55 0 1
Fxc55_54 x55 0 Vx54 -3.29267026253675
Cx55 x55 xm55 2.48872873814249e-13
Vx55 xm55 0 0
Gx55_4 x55 0 u4 0 3.03412643630168
Rx56 x56 0 1
Fxc56_57 x56 0 Vx57 0.810465259407371
Cx56 x56 xm56 5.73542300623674e-13
Vx56 xm56 0 0
Gx56_4 x56 0 u4 0 -0.319432728056736
Rx57 x57 0 1
Fxc57_56 x57 0 Vx56 -2.87557323222599
Cx57 x57 xm57 5.73542300623674e-13
Vx57 xm57 0 0
Gx57_4 x57 0 u4 0 0.918552202296874
Rx58 x58 0 1
Fxc58_59 x58 0 Vx59 3.37705401997148
Cx58 x58 xm58 1.54708334659554e-13
Vx58 xm58 0 0
Gx58_4 x58 0 u4 0 -0.223582926584325
Rx59 x59 0 1
Fxc59_58 x59 0 Vx58 -4.50762230484754
Cx59 x59 xm59 1.54708334659554e-13
Vx59 xm59 0 0
Gx59_4 x59 0 u4 0 1.00782738685459
Rx60 x60 0 1
Fxc60_61 x60 0 Vx61 4.50612019252989
Cx60 x60 xm60 8.01223469558054e-14
Vx60 xm60 0 0
Gx60_4 x60 0 u4 0 -0.0104093377951263
Rx61 x61 0 1
Fxc61_60 x61 0 Vx60 -10.3812565925449
Cx61 x61 xm61 8.01223469558054e-14
Vx61 xm61 0 0
Gx61_4 x61 0 u4 0 0.108062006609682
Rx62 x62 0 1
Fxc62_63 x62 0 Vx63 0.69414631043175
Cx62 x62 xm62 2.64430998425627e-12
Vx62 xm62 0 0
Gx62_4 x62 0 u4 0 -0.535401501946298
Rx63 x63 0 1
Fxc63_62 x63 0 Vx62 -0.815569908018559
Cx63 x63 xm63 2.64430998425627e-12
Vx63 xm63 0 0
Gx63_4 x63 0 u4 0 0.43665735369534
Rx64 x64 0 1
Fxc64_65 x64 0 Vx65 0.904927542082861
Cx64 x64 xm64 1.76980191855023e-12
Vx64 xm64 0 0
Gx64_4 x64 0 u4 0 -0.568546424084988
Rx65 x65 0 1
Fxc65_64 x65 0 Vx64 -1.68847191542929
Cx65 x65 xm65 1.76980191855023e-12
Vx65 xm65 0 0
Gx65_4 x65 0 u4 0 0.959974669685255
Rx66 x66 0 1
Fxc66_67 x66 0 Vx67 21.9295551005288
Cx66 x66 xm66 2.89949926104046e-14
Vx66 xm66 0 0
Gx66_4 x66 0 u4 0 -0.00091115630859902
Rx67 x67 0 1
Fxc67_66 x67 0 Vx66 -12.3928752529334
Cx67 x67 xm67 2.89949926104046e-14
Vx67 xm67 0 0
Gx67_4 x67 0 u4 0 0.011291846468391
Rx68 x68 0 1
Cx68 x68 0 1.21923886393338e-11
Gx68_4 x68 0 u4 0 -0.0374585686630111
Rx69 x69 0 1
Fxc69_70 x69 0 Vx70 0.0601579450056692
Cx69 x69 xm69 4.04258367169137e-13
Vx69 xm69 0 0
Gx69_5 x69 0 u5 0 -0.995988066186022
Rx70 x70 0 1
Fxc70_69 x70 0 Vx69 -2.54068139714307
Cx70 x70 xm70 4.04258367169137e-13
Vx70 xm70 0 0
Gx70_5 x70 0 u5 0 2.53048835153532
Rx71 x71 0 1
Fxc71_72 x71 0 Vx72 1.53573090694534
Cx71 x71 xm71 2.48872873814249e-13
Vx71 xm71 0 0
Gx71_5 x71 0 u5 0 -0.619351616889637
Rx72 x72 0 1
Fxc72_71 x72 0 Vx71 -3.29312536432356
Cx72 x72 xm72 2.48872873814249e-13
Vx72 xm72 0 0
Gx72_5 x72 0 u5 0 2.03960251901407
Rx73 x73 0 1
Fxc73_74 x73 0 Vx74 1.96361497734499
Cx73 x73 xm73 5.73542300623674e-13
Vx73 xm73 0 0
Gx73_5 x73 0 u5 0 -0.551338623712367
Rx74 x74 0 1
Fxc74_73 x74 0 Vx73 -1.1868682162692
Cx74 x74 xm74 5.73542300623674e-13
Vx74 xm74 0 0
Gx74_5 x74 0 u5 0 0.65436628888581
Rx75 x75 0 1
Fxc75_76 x75 0 Vx76 3.56571506653074
Cx75 x75 xm75 1.54708334659554e-13
Vx75 xm75 0 0
Gx75_5 x75 0 u5 0 -0.211102422013723
Rx76 x76 0 1
Fxc76_75 x76 0 Vx75 -4.26912519398505
Cx76 x76 xm76 1.54708334659554e-13
Vx76 xm76 0 0
Gx76_5 x76 0 u5 0 0.901222668330051
Rx77 x77 0 1
Fxc77_78 x77 0 Vx78 8.42357362903806
Cx77 x77 xm77 8.01223469558054e-14
Vx77 xm77 0 0
Gx77_5 x77 0 u5 0 -0.0179598205133261
Rx78 x78 0 1
Fxc78_77 x78 0 Vx77 -5.55336630456246
Cx78 x78 xm78 8.01223469558055e-14
Vx78 xm78 0 0
Gx78_5 x78 0 u5 0 0.0997374620746948
Rx79 x79 0 1
Fxc79_80 x79 0 Vx80 0.984267831887945
Cx79 x79 xm79 2.64430998425627e-12
Vx79 xm79 0 0
Gx79_5 x79 0 u5 0 -0.65225834302634
Rx80 x80 0 1
Fxc80_79 x80 0 Vx79 -0.575173569844651
Cx80 x80 xm80 2.64430998425627e-12
Vx80 xm80 0 0
Gx80_5 x80 0 u5 0 0.375161759619417
Rx81 x81 0 1
Fxc81_82 x81 0 Vx82 0.994908772810352
Cx81 x81 xm81 1.76980191855023e-12
Vx81 xm81 0 0
Gx81_5 x81 0 u5 0 -0.386268420825978
Rx82 x82 0 1
Fxc82_81 x82 0 Vx81 -1.53576366201831
Cx82 x82 xm82 1.76980191855023e-12
Vx82 xm82 0 0
Gx82_5 x82 0 u5 0 0.593217004489733
Rx83 x83 0 1
Fxc83_84 x83 0 Vx84 15.2169063522194
Cx83 x83 xm83 2.89949926104046e-14
Vx83 xm83 0 0
Gx83_5 x83 0 u5 0 -0.000905257712088986
Rx84 x84 0 1
Fxc84_83 x84 0 Vx83 -17.8597564066329
Cx84 x84 xm84 2.89949926104046e-14
Vx84 xm84 0 0
Gx84_5 x84 0 u5 0 0.0161676822231351
Rx85 x85 0 1
Cx85 x85 0 1.21923886393338e-11
Gx85_5 x85 0 u5 0 -0.0304717164167829
Gyc1_1 y1 0 x1 0 0.339035021824551
Gyc1_2 y1 0 x2 0 -1
Gyc1_3 y1 0 x3 0 -0.0916533605786319
Gyc1_4 y1 0 x4 0 -1
Gyc1_5 y1 0 x5 0 -1
Gyc1_6 y1 0 x6 0 -0.144852977958124
Gyc1_7 y1 0 x7 0 1
Gyc1_8 y1 0 x8 0 0.638070749913162
Gyc1_9 y1 0 x9 0 0.78899456945339
Gyc1_10 y1 0 x10 0 -1
Gyc1_11 y1 0 x11 0 0.0579409781751308
Gyc1_12 y1 0 x12 0 1
Gyc1_13 y1 0 x13 0 -1
Gyc1_14 y1 0 x14 0 -0.488581983856279
Gyc1_15 y1 0 x15 0 -1
Gyc1_16 y1 0 x16 0 1
Gyc1_17 y1 0 x17 0 -1
Gyc1_18 y1 0 x18 0 -0.00437285761296664
Gyc1_19 y1 0 x19 0 -0.614830607892596
Gyc1_20 y1 0 x20 0 0.401201312871389
Gyc1_21 y1 0 x21 0 0.636440147842441
Gyc1_22 y1 0 x22 0 -1
Gyc1_23 y1 0 x23 0 -1
Gyc1_24 y1 0 x24 0 0.0167393429748055
Gyc1_25 y1 0 x25 0 -0.498757823019108
Gyc1_26 y1 0 x26 0 -1
Gyc1_27 y1 0 x27 0 -0.471601339036568
Gyc1_28 y1 0 x28 0 0.0746139574313926
Gyc1_29 y1 0 x29 0 -0.268553465501196
Gyc1_30 y1 0 x30 0 -0.00713583750632193
Gyc1_31 y1 0 x31 0 1
Gyc1_32 y1 0 x32 0 -0.0455342185663393
Gyc1_33 y1 0 x33 0 -0.836323862523275
Gyc1_34 y1 0 x34 0 -0.00248238009914281
Gyc1_35 y1 0 x35 0 0.0516843895008199
Gyc1_36 y1 0 x36 0 0.278740497786038
Gyc1_37 y1 0 x37 0 -0.401497207375487
Gyc1_38 y1 0 x38 0 -0.0741229937042537
Gyc1_39 y1 0 x39 0 1
Gyc1_40 y1 0 x40 0 0.906898747217902
Gyc1_41 y1 0 x41 0 0.0345979556551147
Gyc1_42 y1 0 x42 0 0.0178171359697389
Gyc1_43 y1 0 x43 0 1
Gyc1_44 y1 0 x44 0 0.10871404309888
Gyc1_45 y1 0 x45 0 -0.52195534827041
Gyc1_46 y1 0 x46 0 0.813507864654248
Gyc1_47 y1 0 x47 0 -0.0834703288294573
Gyc1_48 y1 0 x48 0 -1
Gyc1_49 y1 0 x49 0 0.308219630792234
Gyc1_50 y1 0 x50 0 0.218080480513919
Gyc1_51 y1 0 x51 0 -0.103891801771564
Gyc1_52 y1 0 x52 0 0.129842120637847
Gyc1_53 y1 0 x53 0 0.0789513495117119
Gyc1_54 y1 0 x54 0 -0.0552986956750642
Gyc1_55 y1 0 x55 0 -0.286061894283478
Gyc1_56 y1 0 x56 0 -0.994067263194043
Gyc1_57 y1 0 x57 0 1
Gyc1_58 y1 0 x58 0 0.0468550073384366
Gyc1_59 y1 0 x59 0 0.0285854735462725
Gyc1_60 y1 0 x60 0 0.141433005931197
Gyc1_61 y1 0 x61 0 1
Gyc1_62 y1 0 x62 0 0.0421068911819027
Gyc1_63 y1 0 x63 0 -0.902658142062333
Gyc1_64 y1 0 x64 0 1
Gyc1_65 y1 0 x65 0 0.32724324956078
Gyc1_66 y1 0 x66 0 0.590153100356245
Gyc1_67 y1 0 x67 0 0.816668046465937
Gyc1_68 y1 0 x68 0 0.296231048018218
Gyc1_69 y1 0 x69 0 -0.154248112162922
Gyc1_70 y1 0 x70 0 -0.0757043317920713
Gyc1_71 y1 0 x71 0 -0.378641476060732
Gyc1_72 y1 0 x72 0 0.401143036979728
Gyc1_73 y1 0 x73 0 1
Gyc1_74 y1 0 x74 0 -1
Gyc1_75 y1 0 x75 0 0.326164883162716
Gyc1_76 y1 0 x76 0 -0.0104357146529264
Gyc1_77 y1 0 x77 0 0.372983367726076
Gyc1_78 y1 0 x78 0 -1
Gyc1_79 y1 0 x79 0 0.030812197355998
Gyc1_80 y1 0 x80 0 0.618462205346564
Gyc1_81 y1 0 x81 0 -1
Gyc1_82 y1 0 x82 0 -0.394523771393549
Gyc1_83 y1 0 x83 0 0.224141169833467
Gyc1_84 y1 0 x84 0 0.169373989133647
Gyc1_85 y1 0 x85 0 -0.311223674887916
Gyc2_1 y2 0 x1 0 0.196934878414496
Gyc2_2 y2 0 x2 0 0.303328101977641
Gyc2_3 y2 0 x3 0 1
Gyc2_4 y2 0 x4 0 -0.160053267457875
Gyc2_5 y2 0 x5 0 -0.578149292886487
Gyc2_6 y2 0 x6 0 -0.84894122314148
Gyc2_7 y2 0 x7 0 0.276739975968531
Gyc2_8 y2 0 x8 0 -1
Gyc2_9 y2 0 x9 0 -0.827961135450691
Gyc2_10 y2 0 x10 0 -0.956334978652414
Gyc2_11 y2 0 x11 0 -1
Gyc2_12 y2 0 x12 0 -0.0342886164184247
Gyc2_13 y2 0 x13 0 0.0866742712714111
Gyc2_14 y2 0 x14 0 0.592750416399898
Gyc2_15 y2 0 x15 0 0.682207739752682
Gyc2_16 y2 0 x16 0 -0.0504755548542359
Gyc2_17 y2 0 x17 0 0.254364107681392
Gyc2_18 y2 0 x18 0 -0.942057904248932
Gyc2_19 y2 0 x19 0 -0.212014418410507
Gyc2_20 y2 0 x20 0 1
Gyc2_21 y2 0 x21 0 -0.524751251047906
Gyc2_22 y2 0 x22 0 0.253598141740166
Gyc2_23 y2 0 x23 0 -0.726460391489413
Gyc2_24 y2 0 x24 0 -0.742730143173653
Gyc2_25 y2 0 x25 0 0.655647514777554
Gyc2_26 y2 0 x26 0 0.0978093842167875
Gyc2_27 y2 0 x27 0 1
Gyc2_28 y2 0 x28 0 0.239432284779977
Gyc2_29 y2 0 x29 0 -1
Gyc2_30 y2 0 x30 0 -1
Gyc2_31 y2 0 x31 0 0.294220581019197
Gyc2_32 y2 0 x32 0 -1
Gyc2_33 y2 0 x33 0 -0.779440956209152
Gyc2_34 y2 0 x34 0 1
Gyc2_35 y2 0 x35 0 -0.488410519803632
Gyc2_36 y2 0 x36 0 -0.818969929333625
Gyc2_37 y2 0 x37 0 0.358788923089646
Gyc2_38 y2 0 x38 0 -0.483390024796154
Gyc2_39 y2 0 x39 0 0.0567947317536376
Gyc2_40 y2 0 x40 0 0.880761616957833
Gyc2_41 y2 0 x41 0 -0.558980798821669
Gyc2_42 y2 0 x42 0 0.943478720631203
Gyc2_43 y2 0 x43 0 -0.36523039900836
Gyc2_44 y2 0 x44 0 -1
Gyc2_45 y2 0 x45 0 -1
Gyc2_46 y2 0 x46 0 -0.311254450385407
Gyc2_47 y2 0 x47 0 0.380142492461983
Gyc2_48 y2 0 x48 0 -0.197036592657154
Gyc2_49 y2 0 x49 0 0.210946265222369
Gyc2_50 y2 0 x50 0 0.628153293651784
Gyc2_51 y2 0 x51 0 -0.0385447484502599
Gyc2_52 y2 0 x52 0 -0.254812342203225
Gyc2_53 y2 0 x53 0 -0.0164853428799748
Gyc2_54 y2 0 x54 0 0.571676388134446
Gyc2_55 y2 0 x55 0 0.138756262664679
Gyc2_56 y2 0 x56 0 -0.668524580847867
Gyc2_57 y2 0 x57 0 -0.00820062619684234
Gyc2_58 y2 0 x58 0 -0.890474603361908
Gyc2_59 y2 0 x59 0 -0.216257104224996
Gyc2_60 y2 0 x60 0 1
Gyc2_61 y2 0 x61 0 -0.362299894081185
Gyc2_62 y2 0 x62 0 1
Gyc2_63 y2 0 x63 0 -0.363717407849479
Gyc2_64 y2 0 x64 0 0.00382613681650455
Gyc2_65 y2 0 x65 0 0.390029016783547
Gyc2_66 y2 0 x66 0 0.098910338162314
Gyc2_67 y2 0 x67 0 0.936941733503279
Gyc2_68 y2 0 x68 0 0.033178764114083
Gyc2_69 y2 0 x69 0 -1
Gyc2_70 y2 0 x70 0 -0.185397242967232
Gyc2_71 y2 0 x71 0 1
Gyc2_72 y2 0 x72 0 0.63671156579508
Gyc2_73 y2 0 x73 0 0.546900343893671
Gyc2_74 y2 0 x74 0 0.415904411754325
Gyc2_75 y2 0 x75 0 -0.704180582877209
Gyc2_76 y2 0 x76 0 -0.43649989680374
Gyc2_77 y2 0 x77 0 -1
Gyc2_78 y2 0 x78 0 0.161695952231879
Gyc2_79 y2 0 x79 0 1
Gyc2_80 y2 0 x80 0 1
Gyc2_81 y2 0 x81 0 0.329731940807028
Gyc2_82 y2 0 x82 0 -1
Gyc2_83 y2 0 x83 0 0.264363944551739
Gyc2_84 y2 0 x84 0 -0.155427582878436
Gyc2_85 y2 0 x85 0 -1
Gyc3_1 y3 0 x1 0 -0.462996075745633
Gyc3_2 y3 0 x2 0 0.0167178225623827
Gyc3_3 y3 0 x3 0 -0.881844509296113
Gyc3_4 y3 0 x4 0 0.591436998405757
Gyc3_5 y3 0 x5 0 0.730553088919637
Gyc3_6 y3 0 x6 0 0.454627982228858
Gyc3_7 y3 0 x7 0 0.0398891993286131
Gyc3_8 y3 0 x8 0 -0.57395586950362
Gyc3_9 y3 0 x9 0 1
Gyc3_10 y3 0 x10 0 0.291225367357547
Gyc3_11 y3 0 x11 0 0.679818982083058
Gyc3_12 y3 0 x12 0 0.065420680290108
Gyc3_13 y3 0 x13 0 -0.212035476962396
Gyc3_14 y3 0 x14 0 -1
Gyc3_15 y3 0 x15 0 0.0636699172357823
Gyc3_16 y3 0 x16 0 0.0741143659263973
Gyc3_17 y3 0 x17 0 -0.483839277047293
Gyc3_18 y3 0 x18 0 -0.621741164878828
Gyc3_19 y3 0 x19 0 -1
Gyc3_20 y3 0 x20 0 0.420196855116853
Gyc3_21 y3 0 x21 0 -0.435147621512357
Gyc3_22 y3 0 x22 0 0.0656700050645491
Gyc3_23 y3 0 x23 0 0.50918692776364
Gyc3_24 y3 0 x24 0 -0.574522356871855
Gyc3_25 y3 0 x25 0 1
Gyc3_26 y3 0 x26 0 -0.368860432943962
Gyc3_27 y3 0 x27 0 -0.676819307593143
Gyc3_28 y3 0 x28 0 -1
Gyc3_29 y3 0 x29 0 -0.18421437573077
Gyc3_30 y3 0 x30 0 0.572523014247762
Gyc3_31 y3 0 x31 0 -0.299563282707213
Gyc3_32 y3 0 x32 0 0.219188896235651
Gyc3_33 y3 0 x33 0 1
Gyc3_34 y3 0 x34 0 -0.0423025908826155
Gyc3_35 y3 0 x35 0 -1
Gyc3_36 y3 0 x36 0 -1
Gyc3_37 y3 0 x37 0 0.873074147176134
Gyc3_38 y3 0 x38 0 -1
Gyc3_39 y3 0 x39 0 -0.167439294603152
Gyc3_40 y3 0 x40 0 -1
Gyc3_41 y3 0 x41 0 -0.922292160353953
Gyc3_42 y3 0 x42 0 1
Gyc3_43 y3 0 x43 0 0.826511914822446
Gyc3_44 y3 0 x44 0 0.483711771924291
Gyc3_45 y3 0 x45 0 0.957799014863482
Gyc3_46 y3 0 x46 0 -1
Gyc3_47 y3 0 x47 0 -1
Gyc3_48 y3 0 x48 0 0.320136002062978
Gyc3_49 y3 0 x49 0 -1
Gyc3_50 y3 0 x50 0 1
Gyc3_51 y3 0 x51 0 1
Gyc3_52 y3 0 x52 0 -1
Gyc3_53 y3 0 x53 0 -0.0243812787486478
Gyc3_54 y3 0 x54 0 1
Gyc3_55 y3 0 x55 0 0.340072591237584
Gyc3_56 y3 0 x56 0 1
Gyc3_57 y3 0 x57 0 -0.125210182469061
Gyc3_58 y3 0 x58 0 -1
Gyc3_59 y3 0 x59 0 -0.431847992180476
Gyc3_60 y3 0 x60 0 -0.384869248254955
Gyc3_61 y3 0 x61 0 0.668404215082296
Gyc3_62 y3 0 x62 0 0.143704043143345
Gyc3_63 y3 0 x63 0 1
Gyc3_64 y3 0 x64 0 0.385931555805158
Gyc3_65 y3 0 x65 0 -1
Gyc3_66 y3 0 x66 0 -0.782080170975446
Gyc3_67 y3 0 x67 0 -1
Gyc3_68 y3 0 x68 0 -1
Gyc3_69 y3 0 x69 0 -0.394471892697604
Gyc3_70 y3 0 x70 0 -0.057712236078707
Gyc3_71 y3 0 x71 0 0.898195499370923
Gyc3_72 y3 0 x72 0 0.238238799001927
Gyc3_73 y3 0 x73 0 -0.348016589169557
Gyc3_74 y3 0 x74 0 -0.0626494167078345
Gyc3_75 y3 0 x75 0 -1
Gyc3_76 y3 0 x76 0 -0.251597262902554
Gyc3_77 y3 0 x77 0 0.682508746560171
Gyc3_78 y3 0 x78 0 -0.538886691857149
Gyc3_79 y3 0 x79 0 0.656026608044531
Gyc3_80 y3 0 x80 0 -0.494559454381746
Gyc3_81 y3 0 x81 0 0.048197671961354
Gyc3_82 y3 0 x82 0 0.635781574247197
Gyc3_83 y3 0 x83 0 -0.862170886837398
Gyc3_84 y3 0 x84 0 0.540794458729652
Gyc3_85 y3 0 x85 0 0.0629837176995262
Gyc4_1 y4 0 x1 0 1
Gyc4_2 y4 0 x2 0 -0.597056859153294
Gyc4_3 y4 0 x3 0 -0.917621052197349
Gyc4_4 y4 0 x4 0 -0.32639464714227
Gyc4_5 y4 0 x5 0 -0.40262094778127
Gyc4_6 y4 0 x6 0 1
Gyc4_7 y4 0 x7 0 0.302417780098417
Gyc4_8 y4 0 x8 0 -0.96013481531636
Gyc4_9 y4 0 x9 0 0.00248913634519794
Gyc4_10 y4 0 x10 0 0.793759801015586
Gyc4_11 y4 0 x11 0 0.0157770632870554
Gyc4_12 y4 0 x12 0 -0.00920433236166329
Gyc4_13 y4 0 x13 0 0.626168607831111
Gyc4_14 y4 0 x14 0 0.22694393090793
Gyc4_15 y4 0 x15 0 -0.18621884345292
Gyc4_16 y4 0 x16 0 -0.0261203453218037
Gyc4_17 y4 0 x17 0 0.734381697288191
Gyc4_18 y4 0 x18 0 -0.328468288654103
Gyc4_19 y4 0 x19 0 -0.257567613766872
Gyc4_20 y4 0 x20 0 0.718649749200692
Gyc4_21 y4 0 x21 0 0.389696442156303
Gyc4_22 y4 0 x22 0 -0.345358970314574
Gyc4_23 y4 0 x23 0 0.0277878151811866
Gyc4_24 y4 0 x24 0 -1
Gyc4_25 y4 0 x25 0 -0.363458455810275
Gyc4_26 y4 0 x26 0 0.421602314949006
Gyc4_27 y4 0 x27 0 -0.192700041913574
Gyc4_28 y4 0 x28 0 0.598206692339817
Gyc4_29 y4 0 x29 0 -0.138572508295619
Gyc4_30 y4 0 x30 0 0.000627210812838855
Gyc4_31 y4 0 x31 0 0.458972340137375
Gyc4_32 y4 0 x32 0 -0.0404458173018481
Gyc4_33 y4 0 x33 0 0.516964263882003
Gyc4_34 y4 0 x34 0 -0.00205667345733354
Gyc4_35 y4 0 x35 0 -0.964813322162432
Gyc4_36 y4 0 x36 0 -0.0159496515746026
Gyc4_37 y4 0 x37 0 1
Gyc4_38 y4 0 x38 0 0.860051605941147
Gyc4_39 y4 0 x39 0 0.425665610407373
Gyc4_40 y4 0 x40 0 -0.267757633858044
Gyc4_41 y4 0 x41 0 -1
Gyc4_42 y4 0 x42 0 -0.638444315629917
Gyc4_43 y4 0 x43 0 -0.0939516291520731
Gyc4_44 y4 0 x44 0 0.587873284360162
Gyc4_45 y4 0 x45 0 0.0695673232270076
Gyc4_46 y4 0 x46 0 0.66728646261518
Gyc4_47 y4 0 x47 0 0.181810430035241
Gyc4_48 y4 0 x48 0 -0.790324513788801
Gyc4_49 y4 0 x49 0 -0.151083787914956
Gyc4_50 y4 0 x50 0 -0.230446836603974
Gyc4_51 y4 0 x51 0 -0.2196200516427
Gyc4_52 y4 0 x52 0 -0.705419647608482
Gyc4_53 y4 0 x53 0 -1
Gyc4_54 y4 0 x54 0 -0.0764209076622422
Gyc4_55 y4 0 x55 0 1
Gyc4_56 y4 0 x56 0 0.0899806577856036
Gyc4_57 y4 0 x57 0 0.552005195543537
Gyc4_58 y4 0 x58 0 0.0278079853259282
Gyc4_59 y4 0 x59 0 -1
Gyc4_60 y4 0 x60 0 -0.873296723977377
Gyc4_61 y4 0 x61 0 -0.260188787684555
Gyc4_62 y4 0 x62 0 -0.694655555107225
Gyc4_63 y4 0 x63 0 -0.13091395653776
Gyc4_64 y4 0 x64 0 0.583145033536774
Gyc4_65 y4 0 x65 0 0.407734992253837
Gyc4_66 y4 0 x66 0 -0.975150542502986
Gyc4_67 y4 0 x67 0 -0.311565936322556
Gyc4_68 y4 0 x68 0 0.310562838365752
Gyc4_69 y4 0 x69 0 -0.641428516886298
Gyc4_70 y4 0 x70 0 -0.724737063368864
Gyc4_71 y4 0 x71 0 0.102585376003303
Gyc4_72 y4 0 x72 0 0.995646527547944
Gyc4_73 y4 0 x73 0 0.0127038129225391
Gyc4_74 y4 0 x74 0 -0.369963186315107
Gyc4_75 y4 0 x75 0 -0.0745286590453808
Gyc4_76 y4 0 x76 0 -1
Gyc4_77 y4 0 x77 0 0.244128383624895
Gyc4_78 y4 0 x78 0 0.348687310792572
Gyc4_79 y4 0 x79 0 -0.0948254690667678
Gyc4_80 y4 0 x80 0 0.445585816621434
Gyc4_81 y4 0 x81 0 -0.38116238202789
Gyc4_82 y4 0 x82 0 -0.0633521930097231
Gyc4_83 y4 0 x83 0 -1
Gyc4_84 y4 0 x84 0 -0.131355680396489
Gyc4_85 y4 0 x85 0 0.110695081139258
Gyc5_1 y5 0 x1 0 -0.994669134887232
Gyc5_2 y5 0 x2 0 0.430065269327175
Gyc5_3 y5 0 x3 0 0.0897672810797741
Gyc5_4 y5 0 x4 0 0.791140740848131
Gyc5_5 y5 0 x5 0 0.587970993039595
Gyc5_6 y5 0 x6 0 -0.733166315473531
Gyc5_7 y5 0 x7 0 0.887913633081552
Gyc5_8 y5 0 x8 0 0.433403564650529
Gyc5_9 y5 0 x9 0 0.343047083623764
Gyc5_10 y5 0 x10 0 -0.839589804541024
Gyc5_11 y5 0 x11 0 0.30433156681085
Gyc5_12 y5 0 x12 0 -0.0393564884759102
Gyc5_13 y5 0 x13 0 -0.360704500913161
Gyc5_14 y5 0 x14 0 -0.050243694136492
Gyc5_15 y5 0 x15 0 0.254244918559922
Gyc5_16 y5 0 x16 0 0.0850405440572205
Gyc5_17 y5 0 x17 0 -0.47849048092225
Gyc5_18 y5 0 x18 0 -1
Gyc5_19 y5 0 x19 0 -0.720915256335284
Gyc5_20 y5 0 x20 0 0.862596718008626
Gyc5_21 y5 0 x21 0 1
Gyc5_22 y5 0 x22 0 0.482572114879665
Gyc5_23 y5 0 x23 0 0.366586881853763
Gyc5_24 y5 0 x24 0 -0.727214251814403
Gyc5_25 y5 0 x25 0 -0.588840027508732
Gyc5_26 y5 0 x26 0 -0.773123922758661
Gyc5_27 y5 0 x27 0 0.12385007628902
Gyc5_28 y5 0 x28 0 0.72780226489256
Gyc5_29 y5 0 x29 0 0.335305533521853
Gyc5_30 y5 0 x30 0 0.164781491885039
Gyc5_31 y5 0 x31 0 -0.752276358655302
Gyc5_32 y5 0 x32 0 0.0160313505629128
Gyc5_33 y5 0 x33 0 0.0233726076364715
Gyc5_34 y5 0 x34 0 -0.21712996495683
Gyc5_35 y5 0 x35 0 -0.251139314839159
Gyc5_36 y5 0 x36 0 -0.100285545471539
Gyc5_37 y5 0 x37 0 0.582633406238077
Gyc5_38 y5 0 x38 0 0.418502026656654
Gyc5_39 y5 0 x39 0 -0.266217839562601
Gyc5_40 y5 0 x40 0 -0.0803636311763337
Gyc5_41 y5 0 x41 0 -0.961707969966839
Gyc5_42 y5 0 x42 0 -0.362722730385959
Gyc5_43 y5 0 x43 0 0.55658788051694
Gyc5_44 y5 0 x44 0 -0.390063950551433
Gyc5_45 y5 0 x45 0 0.491365259671078
Gyc5_46 y5 0 x46 0 -0.291086535759003
Gyc5_47 y5 0 x47 0 0.0151471844557316
Gyc5_48 y5 0 x48 0 0.309297122244333
Gyc5_49 y5 0 x49 0 -0.149502149369882
Gyc5_50 y5 0 x50 0 0.221464151844154
Gyc5_51 y5 0 x51 0 0.00776216794281941
Gyc5_52 y5 0 x52 0 -0.471853393782926
Gyc5_53 y5 0 x53 0 -0.478233765271315
Gyc5_54 y5 0 x54 0 0.0689444450918394
Gyc5_55 y5 0 x55 0 0.672338137421867
Gyc5_56 y5 0 x56 0 0.0225495984956729
Gyc5_57 y5 0 x57 0 -0.262015209618883
Gyc5_58 y5 0 x58 0 -0.0748731281344921
Gyc5_59 y5 0 x59 0 -0.895638777738417
Gyc5_60 y5 0 x60 0 0.411025910917312
Gyc5_61 y5 0 x61 0 0.304036587963951
Gyc5_62 y5 0 x62 0 -0.116872564982119
Gyc5_63 y5 0 x63 0 0.383403257837008
Gyc5_64 y5 0 x64 0 -0.259049229767651
Gyc5_65 y5 0 x65 0 -0.0394756815188903
Gyc5_66 y5 0 x66 0 -1
Gyc5_67 y5 0 x67 0 -0.262933539268381
Gyc5_68 y5 0 x68 0 0.0887199617579333
Gyc5_69 y5 0 x69 0 0.185693497359041
Gyc5_70 y5 0 x70 0 -1
Gyc5_71 y5 0 x71 0 -0.427428650730565
Gyc5_72 y5 0 x72 0 1
Gyc5_73 y5 0 x73 0 -0.307453483059728
Gyc5_74 y5 0 x74 0 0.654101277961753
Gyc5_75 y5 0 x75 0 0.150978212383388
Gyc5_76 y5 0 x76 0 -0.750850483087651
Gyc5_77 y5 0 x77 0 -0.226431777578106
Gyc5_78 y5 0 x78 0 -0.76358620331557
Gyc5_79 y5 0 x79 0 -0.804462349070343
Gyc5_80 y5 0 x80 0 0.374616435574235
Gyc5_81 y5 0 x81 0 0.547830186934543
Gyc5_82 y5 0 x82 0 0.333657141876079
Gyc5_83 y5 0 x83 0 -0.519714025791053
Gyc5_84 y5 0 x84 0 1
Gyc5_85 y5 0 x85 0 0.503409140822947
.ENDS
