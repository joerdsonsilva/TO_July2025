* Equivalent circuit model for E:\touchstone_files\PA_matching_net_2_test.ckt
.SUBCKT PA_matching_net_2_test po1 po2
Vsp1 po1 p1 0
Vsr1 p1 pr1 0
Rp1 pr1 0 50
Ru1 u1 0 50
Fr1 u1 0 Vsr1 -1
Fu1 u1 0 Vsp1 -1
Ry1 y1 0 1
Gy1 p1 0 y1 0 -0.02
Vsp2 po2 p2 0
Vsr2 p2 pr2 0
Rp2 pr2 0 50
Ru2 u2 0 50
Fr2 u2 0 Vsr2 -1
Fu2 u2 0 Vsp2 -1
Ry2 y2 0 1
Gy2 p2 0 y2 0 -0.02
Rx1 x1 0 1
Fxc1_2 x1 0 Vx2 0.877356894846888
Cx1 x1 xm1 1.8152392877893e-13
Vx1 xm1 0 0
Gx1_1 x1 0 u1 0 -0.296707520041198
Rx2 x2 0 1
Fxc2_1 x2 0 Vx1 -5.67095635927009
Cx2 x2 xm2 1.8152392877893e-13
Vx2 xm2 0 0
Gx2_1 x2 0 u1 0 1.68261539762089
Rx3 x3 0 1
Fxc3_4 x3 0 Vx4 4.9495421642561
Cx3 x3 xm3 2.79938439155712e-13
Vx3 xm3 0 0
Gx3_1 x3 0 u1 0 -0.282746937342753
Rx4 x4 0 1
Fxc4_3 x4 0 Vx3 -1.37903744015059
Cx4 x4 xm4 2.79938439155712e-13
Vx4 xm4 0 0
Gx4_1 x4 0 u1 0 0.389918612683569
Rx5 x5 0 1
Fxc5_6 x5 0 Vx6 4.87308269404126
Cx5 x5 xm5 3.16454006813222e-13
Vx5 xm5 0 0
Gx5_1 x5 0 u1 0 -0.301158710455179
Rx6 x6 0 1
Fxc6_5 x6 0 Vx5 -2.07293485811259
Cx6 x6 xm6 3.16454006813222e-13
Vx6 xm6 0 0
Gx6_1 x6 0 u1 0 0.624282388726778
Rx7 x7 0 1
Fxc7_8 x7 0 Vx8 1.19535505024699
Cx7 x7 xm7 9.07193266225332e-14
Vx7 xm7 0 0
Gx7_1 x7 0 u1 0 -0.00872858083303265
Rx8 x8 0 1
Fxc8_7 x8 0 Vx7 -44.7094779046097
Cx8 x8 xm8 9.07193266225332e-14
Vx8 xm8 0 0
Gx8_1 x8 0 u1 0 0.390250291893073
Rx9 x9 0 1
Fxc9_10 x9 0 Vx10 2.41663472205871
Cx9 x9 xm9 4.92494837042492e-14
Vx9 xm9 0 0
Gx9_1 x9 0 u1 0 -0.00212896810250844
Rx10 x10 0 1
Fxc10_9 x10 0 Vx9 -66.8770632224218
Cx10 x10 xm10 4.92494837042492e-14
Vx10 xm10 0 0
Gx10_1 x10 0 u1 0 0.142379134389977
Rx11 x11 0 1
Fxc11_12 x11 0 Vx12 3.89744726269577
Cx11 x11 xm11 8.77500191030632e-12
Vx11 xm11 0 0
Gx11_1 x11 0 u1 0 -2.27091023773636
Rx12 x12 0 1
Fxc12_11 x12 0 Vx11 -0.0167375176951616
Cx12 x12 xm12 8.77500191030632e-12
Vx12 xm12 0 0
Gx12_1 x12 0 u1 0 0.038009400288236
Rx13 x13 0 1
Fxc13_14 x13 0 Vx14 519.955808417539
Cx13 x13 xm13 1.58176529186556e-14
Vx13 xm13 0 0
Gx13_1 x13 0 u1 0 -5.94191430047931e-05
Rx14 x14 0 1
Fxc14_13 x14 0 Vx13 -2.33997643640435
Cx14 x14 xm14 1.58176529186556e-14
Vx14 xm14 0 0
Gx14_1 x14 0 u1 0 0.000139039394502556
Rx15 x15 0 1
Cx15 x15 0 8.92607170697489e-14
Gx15_1 x15 0 u1 0 -0.752429939475891
Rx16 x16 0 1
Fxc16_17 x16 0 Vx17 0.62954556113936
Cx16 x16 xm16 1.8152392877893e-13
Vx16 xm16 0 0
Gx16_2 x16 0 u2 0 -0.323833220625508
Rx17 x17 0 1
Fxc17_16 x17 0 Vx16 -7.90324476782392
Cx17 x17 xm17 1.8152392877893e-13
Vx17 xm17 0 0
Gx17_2 x17 0 u2 0 2.55933320655611
Rx18 x18 0 1
Fxc18_19 x18 0 Vx19 20.8262547988702
Cx18 x18 xm18 2.79938439155712e-13
Vx18 xm18 0 0
Gx18_2 x18 0 u2 0 -1.41088322898722
Rx19 x19 0 1
Fxc19_18 x19 0 Vx18 -0.327740346117507
Cx19 x19 xm19 2.79938439155712e-13
Vx19 xm19 0 0
Gx19_2 x19 0 u2 0 0.462403357799658
Rx20 x20 0 1
Fxc20_21 x20 0 Vx21 2.51228867430863
Cx20 x20 xm20 3.16454006813222e-13
Vx20 xm20 0 0
Gx20_2 x20 0 u2 0 -0.302278169937395
Rx21 x21 0 1
Fxc21_20 x21 0 Vx20 -4.0208687346502
Cx21 x21 xm21 3.16454006813222e-13
Vx21 xm21 0 0
Gx21_2 x21 0 u2 0 1.21542084266855
Rx22 x22 0 1
Fxc22_23 x22 0 Vx23 2.41660282137222
Cx22 x22 xm22 9.07193266225332e-14
Vx22 xm22 0 0
Gx22_2 x22 0 u2 0 -0.0226903083481013
Rx23 x23 0 1
Fxc23_22 x23 0 Vx22 -22.115218824761
Cx23 x23 xm23 9.07193266225332e-14
Vx23 xm23 0 0
Gx23_2 x23 0 u2 0 0.501801134319561
Rx24 x24 0 1
Fxc24_25 x24 0 Vx25 3.71207314209616
Cx24 x24 xm24 4.92494837042492e-14
Vx24 xm24 0 0
Gx24_2 x24 0 u2 0 -0.00231077502814727
Rx25 x25 0 1
Fxc25_24 x25 0 Vx24 -43.5383212846276
Cx25 x25 xm25 4.92494837042492e-14
Vx25 xm25 0 0
Gx25_2 x25 0 u2 0 0.10060726559197
Rx26 x26 0 1
Fxc26_27 x26 0 Vx27 1.95538129154515
Cx26 x26 xm26 8.77500191030632e-12
Vx26 xm26 0 0
Gx26_2 x26 0 u2 0 -0.331942699712148
Rx27 x27 0 1
Fxc27_26 x27 0 Vx26 -0.033361059966868
Cx27 x27 xm27 8.77500191030632e-12
Vx27 xm27 0 0
Gx27_2 x27 0 u2 0 0.011073960310661
Rx28 x28 0 1
Fxc28_29 x28 0 Vx29 43.8075881953164
Cx28 x28 xm28 1.58176529186556e-14
Vx28 xm28 0 0
Gx28_2 x28 0 u2 0 -6.29027018934721e-05
Rx29 x29 0 1
Fxc29_28 x29 0 Vx28 -27.7733696327683
Cx29 x29 xm29 1.58176529186556e-14
Vx29 xm29 0 0
Gx29_2 x29 0 u2 0 0.00174701999058723
Rx30 x30 0 1
Cx30 x30 0 8.92607170697489e-14
Gx30_2 x30 0 u2 0 -0.571854057492604
Gyc1_1 y1 0 x1 0 -1
Gyc1_2 y1 0 x2 0 -1
Gyc1_3 y1 0 x3 0 -1
Gyc1_4 y1 0 x4 0 -1
Gyc1_5 y1 0 x5 0 -0.942194346403909
Gyc1_6 y1 0 x6 0 1
Gyc1_7 y1 0 x7 0 -1
Gyc1_8 y1 0 x8 0 -0.341726308384708
Gyc1_9 y1 0 x9 0 1
Gyc1_10 y1 0 x10 0 1
Gyc1_11 y1 0 x11 0 -1
Gyc1_12 y1 0 x12 0 1
Gyc1_13 y1 0 x13 0 1
Gyc1_14 y1 0 x14 0 -0.79961808976962
Gyc1_15 y1 0 x15 0 1
Gyc1_16 y1 0 x16 0 -0.139874015741676
Gyc1_17 y1 0 x17 0 -0.0421735366450854
Gyc1_18 y1 0 x18 0 -0.189192157584381
Gyc1_19 y1 0 x19 0 -0.757153787654625
Gyc1_20 y1 0 x20 0 1
Gyc1_21 y1 0 x21 0 0.453686775804889
Gyc1_22 y1 0 x22 0 0.107735751250936
Gyc1_23 y1 0 x23 0 0.773218771718483
Gyc1_24 y1 0 x24 0 -0.713010782662968
Gyc1_25 y1 0 x25 0 -1
Gyc1_26 y1 0 x26 0 1
Gyc1_27 y1 0 x27 0 -0.458524116606749
Gyc1_28 y1 0 x28 0 -1
Gyc1_29 y1 0 x29 0 -0.518702991676871
Gyc1_30 y1 0 x30 0 0.0880717753015603
Gyc2_1 y2 0 x1 0 -0.185207775234193
Gyc2_2 y2 0 x2 0 -0.0645487626326866
Gyc2_3 y2 0 x3 0 -0.934473470149422
Gyc2_4 y2 0 x4 0 -0.909203502932849
Gyc2_5 y2 0 x5 0 1
Gyc2_6 y2 0 x6 0 0.886918425369786
Gyc2_7 y2 0 x7 0 0.369315779020545
Gyc2_8 y2 0 x8 0 1
Gyc2_9 y2 0 x9 0 -0.827598263713025
Gyc2_10 y2 0 x10 0 -0.687842848906403
Gyc2_11 y2 0 x11 0 0.143964013931089
Gyc2_12 y2 0 x12 0 -0.215380351776669
Gyc2_13 y2 0 x13 0 -0.984013081116896
Gyc2_14 y2 0 x14 0 -1
Gyc2_15 y2 0 x15 0 0.0837062916606862
Gyc2_16 y2 0 x16 0 -1
Gyc2_17 y2 0 x17 0 1
Gyc2_18 y2 0 x18 0 1
Gyc2_19 y2 0 x19 0 -1
Gyc2_20 y2 0 x20 0 -0.144745849326089
Gyc2_21 y2 0 x21 0 -1
Gyc2_22 y2 0 x22 0 1
Gyc2_23 y2 0 x23 0 1
Gyc2_24 y2 0 x24 0 1
Gyc2_25 y2 0 x25 0 0.670810306731329
Gyc2_26 y2 0 x26 0 -0.104693801148755
Gyc2_27 y2 0 x27 0 1
Gyc2_28 y2 0 x28 0 0.576551037549243
Gyc2_29 y2 0 x29 0 1
Gyc2_30 y2 0 x30 0 -1
.ENDS
